* Generated by gen_array.py — DO NOT EDIT by hand.
* Regenerate: python3 gen_array.py --routing 16
* Routing layer link: 16 ascending SFs + 16×16 routing matrix.
* Routing cells: 256 XMPRED + 256 Cw_route + 256 MN4_r + 256 hebbian_mult
*
* See pred_code_networks.md §42 for design rationale.

.subckt layer_link_route_16
+ iout_lower_0  iout_lower_1  iout_lower_2  iout_lower_3  iout_lower_4  iout_lower_5  iout_lower_6  iout_lower_7  iout_lower_8  iout_lower_9  iout_lower_10  iout_lower_11  iout_lower_12  iout_lower_13  iout_lower_14  iout_lower_15
+ inp_upper_0  inp_upper_1  inp_upper_2  inp_upper_3  inp_upper_4  inp_upper_5  inp_upper_6  inp_upper_7  inp_upper_8  inp_upper_9  inp_upper_10  inp_upper_11  inp_upper_12  inp_upper_13  inp_upper_14  inp_upper_15
+ i_pred_0  i_pred_1  i_pred_2  i_pred_3  i_pred_4  i_pred_5  i_pred_6  i_pred_7  i_pred_8  i_pred_9  i_pred_10  i_pred_11  i_pred_12  i_pred_13  i_pred_14  i_pred_15
+ iout_upper_0  iout_upper_1  iout_upper_2  iout_upper_3  iout_upper_4  iout_upper_5  iout_upper_6  iout_upper_7  iout_upper_8  iout_upper_9  iout_upper_10  iout_upper_11  iout_upper_12  iout_upper_13  iout_upper_14  iout_upper_15
+ ierr_dig_0  ierr_dig_1  ierr_dig_2  ierr_dig_3  ierr_dig_4  ierr_dig_5  ierr_dig_6  ierr_dig_7  ierr_dig_8  ierr_dig_9  ierr_dig_10  ierr_dig_11  ierr_dig_12  ierr_dig_13  ierr_dig_14  ierr_dig_15
+ we_route
+ vcm_route vcm_upper vcm_iout vbias_n vdd vss

* ──────────────────────────────────────────────────────────────────────────
* ASCENDING PATH: 16 PMOS source followers  iout_lower_r → inp_upper_r
* V(inp_upper) = V(iout_lower) + |Vgs_P| ≈ +0.65V (§71 PMOS SF fix)
* ──────────────────────────────────────────────────────────────────────────
* Row 0
XMSF_0   n_sf_d_0  iout_lower_0  inp_upper_0  vdd   sky130_fd_pr__pfet_01v8  w=4  l=0.5
XMTAIL_0  n_sf_d_0  vbias_n  vss  vss   sky130_fd_pr__nfet_01v8  w=2  l=1
* Row 1
XMSF_1   n_sf_d_1  iout_lower_1  inp_upper_1  vdd   sky130_fd_pr__pfet_01v8  w=4  l=0.5
XMTAIL_1  n_sf_d_1  vbias_n  vss  vss   sky130_fd_pr__nfet_01v8  w=2  l=1
* Row 2
XMSF_2   n_sf_d_2  iout_lower_2  inp_upper_2  vdd   sky130_fd_pr__pfet_01v8  w=4  l=0.5
XMTAIL_2  n_sf_d_2  vbias_n  vss  vss   sky130_fd_pr__nfet_01v8  w=2  l=1
* Row 3
XMSF_3   n_sf_d_3  iout_lower_3  inp_upper_3  vdd   sky130_fd_pr__pfet_01v8  w=4  l=0.5
XMTAIL_3  n_sf_d_3  vbias_n  vss  vss   sky130_fd_pr__nfet_01v8  w=2  l=1
* Row 4
XMSF_4   n_sf_d_4  iout_lower_4  inp_upper_4  vdd   sky130_fd_pr__pfet_01v8  w=4  l=0.5
XMTAIL_4  n_sf_d_4  vbias_n  vss  vss   sky130_fd_pr__nfet_01v8  w=2  l=1
* Row 5
XMSF_5   n_sf_d_5  iout_lower_5  inp_upper_5  vdd   sky130_fd_pr__pfet_01v8  w=4  l=0.5
XMTAIL_5  n_sf_d_5  vbias_n  vss  vss   sky130_fd_pr__nfet_01v8  w=2  l=1
* Row 6
XMSF_6   n_sf_d_6  iout_lower_6  inp_upper_6  vdd   sky130_fd_pr__pfet_01v8  w=4  l=0.5
XMTAIL_6  n_sf_d_6  vbias_n  vss  vss   sky130_fd_pr__nfet_01v8  w=2  l=1
* Row 7
XMSF_7   n_sf_d_7  iout_lower_7  inp_upper_7  vdd   sky130_fd_pr__pfet_01v8  w=4  l=0.5
XMTAIL_7  n_sf_d_7  vbias_n  vss  vss   sky130_fd_pr__nfet_01v8  w=2  l=1
* Row 8
XMSF_8   n_sf_d_8  iout_lower_8  inp_upper_8  vdd   sky130_fd_pr__pfet_01v8  w=4  l=0.5
XMTAIL_8  n_sf_d_8  vbias_n  vss  vss   sky130_fd_pr__nfet_01v8  w=2  l=1
* Row 9
XMSF_9   n_sf_d_9  iout_lower_9  inp_upper_9  vdd   sky130_fd_pr__pfet_01v8  w=4  l=0.5
XMTAIL_9  n_sf_d_9  vbias_n  vss  vss   sky130_fd_pr__nfet_01v8  w=2  l=1
* Row 10
XMSF_10   n_sf_d_10  iout_lower_10  inp_upper_10  vdd   sky130_fd_pr__pfet_01v8  w=4  l=0.5
XMTAIL_10  n_sf_d_10  vbias_n  vss  vss   sky130_fd_pr__nfet_01v8  w=2  l=1
* Row 11
XMSF_11   n_sf_d_11  iout_lower_11  inp_upper_11  vdd   sky130_fd_pr__pfet_01v8  w=4  l=0.5
XMTAIL_11  n_sf_d_11  vbias_n  vss  vss   sky130_fd_pr__nfet_01v8  w=2  l=1
* Row 12
XMSF_12   n_sf_d_12  iout_lower_12  inp_upper_12  vdd   sky130_fd_pr__pfet_01v8  w=4  l=0.5
XMTAIL_12  n_sf_d_12  vbias_n  vss  vss   sky130_fd_pr__nfet_01v8  w=2  l=1
* Row 13
XMSF_13   n_sf_d_13  iout_lower_13  inp_upper_13  vdd   sky130_fd_pr__pfet_01v8  w=4  l=0.5
XMTAIL_13  n_sf_d_13  vbias_n  vss  vss   sky130_fd_pr__nfet_01v8  w=2  l=1
* Row 14
XMSF_14   n_sf_d_14  iout_lower_14  inp_upper_14  vdd   sky130_fd_pr__pfet_01v8  w=4  l=0.5
XMTAIL_14  n_sf_d_14  vbias_n  vss  vss   sky130_fd_pr__nfet_01v8  w=2  l=1
* Row 15
XMSF_15   n_sf_d_15  iout_lower_15  inp_upper_15  vdd   sky130_fd_pr__pfet_01v8  w=4  l=0.5
XMTAIL_15  n_sf_d_15  vbias_n  vss  vss   sky130_fd_pr__nfet_01v8  w=2  l=1
* Reference PMOS SF: vcm_iout → vcm_upper (matched shift for inn_col; §72 fix)
XMSF_ref   n_sfref_d  vcm_iout  vcm_upper  vdd   sky130_fd_pr__pfet_01v8  w=4  l=0.5
XMTAIL_ref n_sfref_d  vbias_n  vss  vss   sky130_fd_pr__nfet_01v8  w=2  l=1

* ──────────────────────────────────────────────────────────────────────────
* DESCENDING ROUTING MATRIX: 16×16 = 256 routing cells
*
* For each (dest=d, src=s):
*   XMPRED_r_d_s  — NMOS sinking from i_pred_d; gate=Vw_route_d_s
*   Cw_route_d_s  — 200fF routing weight capacitor (increase to 2p for
*                   10× slower topology timescale vs MAC weights)
*   MN4_r_d_s     — access transistor; gate=we_route
*   X_rhebb_d_s   — hebbian_mult: v_pre=inp_upper_s, vcm=vcm_route, v_post=ierr_dig_d
*                   updates Cw_route when source active AND dest has error
* ──────────────────────────────────────────────────────────────────────────

* ── Destination row 0 ── 16 source connections ──────────────────────────
XMPRED_r_0_0  i_pred_0  vw_route_0_0  vss  vss  sky130_fd_pr__nfet_01v8  w=4  l=0.35
Cw_route_0_0  vw_route_0_0  vss  200f
R_bleed_0_0  vw_route_0_0  vss  10000meg
XMN4_r_0_0  vw_route_0_0  we_route  iwrite_route_0_0  vss  sky130_fd_pr__nfet_01v8  w=0.5  l=0.5
X_rhebb_0_0  iwrite_route_0_0  inp_upper_0  ierr_dig_0  vcm_route  vdd vss  hebbian_mult
XMPRED_r_0_1  i_pred_0  vw_route_0_1  vss  vss  sky130_fd_pr__nfet_01v8  w=4  l=0.35
Cw_route_0_1  vw_route_0_1  vss  200f
R_bleed_0_1  vw_route_0_1  vss  10000meg
XMN4_r_0_1  vw_route_0_1  we_route  iwrite_route_0_1  vss  sky130_fd_pr__nfet_01v8  w=0.5  l=0.5
X_rhebb_0_1  iwrite_route_0_1  inp_upper_1  ierr_dig_0  vcm_route  vdd vss  hebbian_mult
XMPRED_r_0_2  i_pred_0  vw_route_0_2  vss  vss  sky130_fd_pr__nfet_01v8  w=4  l=0.35
Cw_route_0_2  vw_route_0_2  vss  200f
R_bleed_0_2  vw_route_0_2  vss  10000meg
XMN4_r_0_2  vw_route_0_2  we_route  iwrite_route_0_2  vss  sky130_fd_pr__nfet_01v8  w=0.5  l=0.5
X_rhebb_0_2  iwrite_route_0_2  inp_upper_2  ierr_dig_0  vcm_route  vdd vss  hebbian_mult
XMPRED_r_0_3  i_pred_0  vw_route_0_3  vss  vss  sky130_fd_pr__nfet_01v8  w=4  l=0.35
Cw_route_0_3  vw_route_0_3  vss  200f
R_bleed_0_3  vw_route_0_3  vss  10000meg
XMN4_r_0_3  vw_route_0_3  we_route  iwrite_route_0_3  vss  sky130_fd_pr__nfet_01v8  w=0.5  l=0.5
X_rhebb_0_3  iwrite_route_0_3  inp_upper_3  ierr_dig_0  vcm_route  vdd vss  hebbian_mult
XMPRED_r_0_4  i_pred_0  vw_route_0_4  vss  vss  sky130_fd_pr__nfet_01v8  w=4  l=0.35
Cw_route_0_4  vw_route_0_4  vss  200f
R_bleed_0_4  vw_route_0_4  vss  10000meg
XMN4_r_0_4  vw_route_0_4  we_route  iwrite_route_0_4  vss  sky130_fd_pr__nfet_01v8  w=0.5  l=0.5
X_rhebb_0_4  iwrite_route_0_4  inp_upper_4  ierr_dig_0  vcm_route  vdd vss  hebbian_mult
XMPRED_r_0_5  i_pred_0  vw_route_0_5  vss  vss  sky130_fd_pr__nfet_01v8  w=4  l=0.35
Cw_route_0_5  vw_route_0_5  vss  200f
R_bleed_0_5  vw_route_0_5  vss  10000meg
XMN4_r_0_5  vw_route_0_5  we_route  iwrite_route_0_5  vss  sky130_fd_pr__nfet_01v8  w=0.5  l=0.5
X_rhebb_0_5  iwrite_route_0_5  inp_upper_5  ierr_dig_0  vcm_route  vdd vss  hebbian_mult
XMPRED_r_0_6  i_pred_0  vw_route_0_6  vss  vss  sky130_fd_pr__nfet_01v8  w=4  l=0.35
Cw_route_0_6  vw_route_0_6  vss  200f
R_bleed_0_6  vw_route_0_6  vss  10000meg
XMN4_r_0_6  vw_route_0_6  we_route  iwrite_route_0_6  vss  sky130_fd_pr__nfet_01v8  w=0.5  l=0.5
X_rhebb_0_6  iwrite_route_0_6  inp_upper_6  ierr_dig_0  vcm_route  vdd vss  hebbian_mult
XMPRED_r_0_7  i_pred_0  vw_route_0_7  vss  vss  sky130_fd_pr__nfet_01v8  w=4  l=0.35
Cw_route_0_7  vw_route_0_7  vss  200f
R_bleed_0_7  vw_route_0_7  vss  10000meg
XMN4_r_0_7  vw_route_0_7  we_route  iwrite_route_0_7  vss  sky130_fd_pr__nfet_01v8  w=0.5  l=0.5
X_rhebb_0_7  iwrite_route_0_7  inp_upper_7  ierr_dig_0  vcm_route  vdd vss  hebbian_mult
XMPRED_r_0_8  i_pred_0  vw_route_0_8  vss  vss  sky130_fd_pr__nfet_01v8  w=4  l=0.35
Cw_route_0_8  vw_route_0_8  vss  200f
R_bleed_0_8  vw_route_0_8  vss  10000meg
XMN4_r_0_8  vw_route_0_8  we_route  iwrite_route_0_8  vss  sky130_fd_pr__nfet_01v8  w=0.5  l=0.5
X_rhebb_0_8  iwrite_route_0_8  inp_upper_8  ierr_dig_0  vcm_route  vdd vss  hebbian_mult
XMPRED_r_0_9  i_pred_0  vw_route_0_9  vss  vss  sky130_fd_pr__nfet_01v8  w=4  l=0.35
Cw_route_0_9  vw_route_0_9  vss  200f
R_bleed_0_9  vw_route_0_9  vss  10000meg
XMN4_r_0_9  vw_route_0_9  we_route  iwrite_route_0_9  vss  sky130_fd_pr__nfet_01v8  w=0.5  l=0.5
X_rhebb_0_9  iwrite_route_0_9  inp_upper_9  ierr_dig_0  vcm_route  vdd vss  hebbian_mult
XMPRED_r_0_10  i_pred_0  vw_route_0_10  vss  vss  sky130_fd_pr__nfet_01v8  w=4  l=0.35
Cw_route_0_10  vw_route_0_10  vss  200f
R_bleed_0_10  vw_route_0_10  vss  10000meg
XMN4_r_0_10  vw_route_0_10  we_route  iwrite_route_0_10  vss  sky130_fd_pr__nfet_01v8  w=0.5  l=0.5
X_rhebb_0_10  iwrite_route_0_10  inp_upper_10  ierr_dig_0  vcm_route  vdd vss  hebbian_mult
XMPRED_r_0_11  i_pred_0  vw_route_0_11  vss  vss  sky130_fd_pr__nfet_01v8  w=4  l=0.35
Cw_route_0_11  vw_route_0_11  vss  200f
R_bleed_0_11  vw_route_0_11  vss  10000meg
XMN4_r_0_11  vw_route_0_11  we_route  iwrite_route_0_11  vss  sky130_fd_pr__nfet_01v8  w=0.5  l=0.5
X_rhebb_0_11  iwrite_route_0_11  inp_upper_11  ierr_dig_0  vcm_route  vdd vss  hebbian_mult
XMPRED_r_0_12  i_pred_0  vw_route_0_12  vss  vss  sky130_fd_pr__nfet_01v8  w=4  l=0.35
Cw_route_0_12  vw_route_0_12  vss  200f
R_bleed_0_12  vw_route_0_12  vss  10000meg
XMN4_r_0_12  vw_route_0_12  we_route  iwrite_route_0_12  vss  sky130_fd_pr__nfet_01v8  w=0.5  l=0.5
X_rhebb_0_12  iwrite_route_0_12  inp_upper_12  ierr_dig_0  vcm_route  vdd vss  hebbian_mult
XMPRED_r_0_13  i_pred_0  vw_route_0_13  vss  vss  sky130_fd_pr__nfet_01v8  w=4  l=0.35
Cw_route_0_13  vw_route_0_13  vss  200f
R_bleed_0_13  vw_route_0_13  vss  10000meg
XMN4_r_0_13  vw_route_0_13  we_route  iwrite_route_0_13  vss  sky130_fd_pr__nfet_01v8  w=0.5  l=0.5
X_rhebb_0_13  iwrite_route_0_13  inp_upper_13  ierr_dig_0  vcm_route  vdd vss  hebbian_mult
XMPRED_r_0_14  i_pred_0  vw_route_0_14  vss  vss  sky130_fd_pr__nfet_01v8  w=4  l=0.35
Cw_route_0_14  vw_route_0_14  vss  200f
R_bleed_0_14  vw_route_0_14  vss  10000meg
XMN4_r_0_14  vw_route_0_14  we_route  iwrite_route_0_14  vss  sky130_fd_pr__nfet_01v8  w=0.5  l=0.5
X_rhebb_0_14  iwrite_route_0_14  inp_upper_14  ierr_dig_0  vcm_route  vdd vss  hebbian_mult
XMPRED_r_0_15  i_pred_0  vw_route_0_15  vss  vss  sky130_fd_pr__nfet_01v8  w=4  l=0.35
Cw_route_0_15  vw_route_0_15  vss  200f
R_bleed_0_15  vw_route_0_15  vss  10000meg
XMN4_r_0_15  vw_route_0_15  we_route  iwrite_route_0_15  vss  sky130_fd_pr__nfet_01v8  w=0.5  l=0.5
X_rhebb_0_15  iwrite_route_0_15  inp_upper_15  ierr_dig_0  vcm_route  vdd vss  hebbian_mult

* ── Destination row 1 ── 16 source connections ──────────────────────────
XMPRED_r_1_0  i_pred_1  vw_route_1_0  vss  vss  sky130_fd_pr__nfet_01v8  w=4  l=0.35
Cw_route_1_0  vw_route_1_0  vss  200f
R_bleed_1_0  vw_route_1_0  vss  10000meg
XMN4_r_1_0  vw_route_1_0  we_route  iwrite_route_1_0  vss  sky130_fd_pr__nfet_01v8  w=0.5  l=0.5
X_rhebb_1_0  iwrite_route_1_0  inp_upper_0  ierr_dig_1  vcm_route  vdd vss  hebbian_mult
XMPRED_r_1_1  i_pred_1  vw_route_1_1  vss  vss  sky130_fd_pr__nfet_01v8  w=4  l=0.35
Cw_route_1_1  vw_route_1_1  vss  200f
R_bleed_1_1  vw_route_1_1  vss  10000meg
XMN4_r_1_1  vw_route_1_1  we_route  iwrite_route_1_1  vss  sky130_fd_pr__nfet_01v8  w=0.5  l=0.5
X_rhebb_1_1  iwrite_route_1_1  inp_upper_1  ierr_dig_1  vcm_route  vdd vss  hebbian_mult
XMPRED_r_1_2  i_pred_1  vw_route_1_2  vss  vss  sky130_fd_pr__nfet_01v8  w=4  l=0.35
Cw_route_1_2  vw_route_1_2  vss  200f
R_bleed_1_2  vw_route_1_2  vss  10000meg
XMN4_r_1_2  vw_route_1_2  we_route  iwrite_route_1_2  vss  sky130_fd_pr__nfet_01v8  w=0.5  l=0.5
X_rhebb_1_2  iwrite_route_1_2  inp_upper_2  ierr_dig_1  vcm_route  vdd vss  hebbian_mult
XMPRED_r_1_3  i_pred_1  vw_route_1_3  vss  vss  sky130_fd_pr__nfet_01v8  w=4  l=0.35
Cw_route_1_3  vw_route_1_3  vss  200f
R_bleed_1_3  vw_route_1_3  vss  10000meg
XMN4_r_1_3  vw_route_1_3  we_route  iwrite_route_1_3  vss  sky130_fd_pr__nfet_01v8  w=0.5  l=0.5
X_rhebb_1_3  iwrite_route_1_3  inp_upper_3  ierr_dig_1  vcm_route  vdd vss  hebbian_mult
XMPRED_r_1_4  i_pred_1  vw_route_1_4  vss  vss  sky130_fd_pr__nfet_01v8  w=4  l=0.35
Cw_route_1_4  vw_route_1_4  vss  200f
R_bleed_1_4  vw_route_1_4  vss  10000meg
XMN4_r_1_4  vw_route_1_4  we_route  iwrite_route_1_4  vss  sky130_fd_pr__nfet_01v8  w=0.5  l=0.5
X_rhebb_1_4  iwrite_route_1_4  inp_upper_4  ierr_dig_1  vcm_route  vdd vss  hebbian_mult
XMPRED_r_1_5  i_pred_1  vw_route_1_5  vss  vss  sky130_fd_pr__nfet_01v8  w=4  l=0.35
Cw_route_1_5  vw_route_1_5  vss  200f
R_bleed_1_5  vw_route_1_5  vss  10000meg
XMN4_r_1_5  vw_route_1_5  we_route  iwrite_route_1_5  vss  sky130_fd_pr__nfet_01v8  w=0.5  l=0.5
X_rhebb_1_5  iwrite_route_1_5  inp_upper_5  ierr_dig_1  vcm_route  vdd vss  hebbian_mult
XMPRED_r_1_6  i_pred_1  vw_route_1_6  vss  vss  sky130_fd_pr__nfet_01v8  w=4  l=0.35
Cw_route_1_6  vw_route_1_6  vss  200f
R_bleed_1_6  vw_route_1_6  vss  10000meg
XMN4_r_1_6  vw_route_1_6  we_route  iwrite_route_1_6  vss  sky130_fd_pr__nfet_01v8  w=0.5  l=0.5
X_rhebb_1_6  iwrite_route_1_6  inp_upper_6  ierr_dig_1  vcm_route  vdd vss  hebbian_mult
XMPRED_r_1_7  i_pred_1  vw_route_1_7  vss  vss  sky130_fd_pr__nfet_01v8  w=4  l=0.35
Cw_route_1_7  vw_route_1_7  vss  200f
R_bleed_1_7  vw_route_1_7  vss  10000meg
XMN4_r_1_7  vw_route_1_7  we_route  iwrite_route_1_7  vss  sky130_fd_pr__nfet_01v8  w=0.5  l=0.5
X_rhebb_1_7  iwrite_route_1_7  inp_upper_7  ierr_dig_1  vcm_route  vdd vss  hebbian_mult
XMPRED_r_1_8  i_pred_1  vw_route_1_8  vss  vss  sky130_fd_pr__nfet_01v8  w=4  l=0.35
Cw_route_1_8  vw_route_1_8  vss  200f
R_bleed_1_8  vw_route_1_8  vss  10000meg
XMN4_r_1_8  vw_route_1_8  we_route  iwrite_route_1_8  vss  sky130_fd_pr__nfet_01v8  w=0.5  l=0.5
X_rhebb_1_8  iwrite_route_1_8  inp_upper_8  ierr_dig_1  vcm_route  vdd vss  hebbian_mult
XMPRED_r_1_9  i_pred_1  vw_route_1_9  vss  vss  sky130_fd_pr__nfet_01v8  w=4  l=0.35
Cw_route_1_9  vw_route_1_9  vss  200f
R_bleed_1_9  vw_route_1_9  vss  10000meg
XMN4_r_1_9  vw_route_1_9  we_route  iwrite_route_1_9  vss  sky130_fd_pr__nfet_01v8  w=0.5  l=0.5
X_rhebb_1_9  iwrite_route_1_9  inp_upper_9  ierr_dig_1  vcm_route  vdd vss  hebbian_mult
XMPRED_r_1_10  i_pred_1  vw_route_1_10  vss  vss  sky130_fd_pr__nfet_01v8  w=4  l=0.35
Cw_route_1_10  vw_route_1_10  vss  200f
R_bleed_1_10  vw_route_1_10  vss  10000meg
XMN4_r_1_10  vw_route_1_10  we_route  iwrite_route_1_10  vss  sky130_fd_pr__nfet_01v8  w=0.5  l=0.5
X_rhebb_1_10  iwrite_route_1_10  inp_upper_10  ierr_dig_1  vcm_route  vdd vss  hebbian_mult
XMPRED_r_1_11  i_pred_1  vw_route_1_11  vss  vss  sky130_fd_pr__nfet_01v8  w=4  l=0.35
Cw_route_1_11  vw_route_1_11  vss  200f
R_bleed_1_11  vw_route_1_11  vss  10000meg
XMN4_r_1_11  vw_route_1_11  we_route  iwrite_route_1_11  vss  sky130_fd_pr__nfet_01v8  w=0.5  l=0.5
X_rhebb_1_11  iwrite_route_1_11  inp_upper_11  ierr_dig_1  vcm_route  vdd vss  hebbian_mult
XMPRED_r_1_12  i_pred_1  vw_route_1_12  vss  vss  sky130_fd_pr__nfet_01v8  w=4  l=0.35
Cw_route_1_12  vw_route_1_12  vss  200f
R_bleed_1_12  vw_route_1_12  vss  10000meg
XMN4_r_1_12  vw_route_1_12  we_route  iwrite_route_1_12  vss  sky130_fd_pr__nfet_01v8  w=0.5  l=0.5
X_rhebb_1_12  iwrite_route_1_12  inp_upper_12  ierr_dig_1  vcm_route  vdd vss  hebbian_mult
XMPRED_r_1_13  i_pred_1  vw_route_1_13  vss  vss  sky130_fd_pr__nfet_01v8  w=4  l=0.35
Cw_route_1_13  vw_route_1_13  vss  200f
R_bleed_1_13  vw_route_1_13  vss  10000meg
XMN4_r_1_13  vw_route_1_13  we_route  iwrite_route_1_13  vss  sky130_fd_pr__nfet_01v8  w=0.5  l=0.5
X_rhebb_1_13  iwrite_route_1_13  inp_upper_13  ierr_dig_1  vcm_route  vdd vss  hebbian_mult
XMPRED_r_1_14  i_pred_1  vw_route_1_14  vss  vss  sky130_fd_pr__nfet_01v8  w=4  l=0.35
Cw_route_1_14  vw_route_1_14  vss  200f
R_bleed_1_14  vw_route_1_14  vss  10000meg
XMN4_r_1_14  vw_route_1_14  we_route  iwrite_route_1_14  vss  sky130_fd_pr__nfet_01v8  w=0.5  l=0.5
X_rhebb_1_14  iwrite_route_1_14  inp_upper_14  ierr_dig_1  vcm_route  vdd vss  hebbian_mult
XMPRED_r_1_15  i_pred_1  vw_route_1_15  vss  vss  sky130_fd_pr__nfet_01v8  w=4  l=0.35
Cw_route_1_15  vw_route_1_15  vss  200f
R_bleed_1_15  vw_route_1_15  vss  10000meg
XMN4_r_1_15  vw_route_1_15  we_route  iwrite_route_1_15  vss  sky130_fd_pr__nfet_01v8  w=0.5  l=0.5
X_rhebb_1_15  iwrite_route_1_15  inp_upper_15  ierr_dig_1  vcm_route  vdd vss  hebbian_mult

* ── Destination row 2 ── 16 source connections ──────────────────────────
XMPRED_r_2_0  i_pred_2  vw_route_2_0  vss  vss  sky130_fd_pr__nfet_01v8  w=4  l=0.35
Cw_route_2_0  vw_route_2_0  vss  200f
R_bleed_2_0  vw_route_2_0  vss  10000meg
XMN4_r_2_0  vw_route_2_0  we_route  iwrite_route_2_0  vss  sky130_fd_pr__nfet_01v8  w=0.5  l=0.5
X_rhebb_2_0  iwrite_route_2_0  inp_upper_0  ierr_dig_2  vcm_route  vdd vss  hebbian_mult
XMPRED_r_2_1  i_pred_2  vw_route_2_1  vss  vss  sky130_fd_pr__nfet_01v8  w=4  l=0.35
Cw_route_2_1  vw_route_2_1  vss  200f
R_bleed_2_1  vw_route_2_1  vss  10000meg
XMN4_r_2_1  vw_route_2_1  we_route  iwrite_route_2_1  vss  sky130_fd_pr__nfet_01v8  w=0.5  l=0.5
X_rhebb_2_1  iwrite_route_2_1  inp_upper_1  ierr_dig_2  vcm_route  vdd vss  hebbian_mult
XMPRED_r_2_2  i_pred_2  vw_route_2_2  vss  vss  sky130_fd_pr__nfet_01v8  w=4  l=0.35
Cw_route_2_2  vw_route_2_2  vss  200f
R_bleed_2_2  vw_route_2_2  vss  10000meg
XMN4_r_2_2  vw_route_2_2  we_route  iwrite_route_2_2  vss  sky130_fd_pr__nfet_01v8  w=0.5  l=0.5
X_rhebb_2_2  iwrite_route_2_2  inp_upper_2  ierr_dig_2  vcm_route  vdd vss  hebbian_mult
XMPRED_r_2_3  i_pred_2  vw_route_2_3  vss  vss  sky130_fd_pr__nfet_01v8  w=4  l=0.35
Cw_route_2_3  vw_route_2_3  vss  200f
R_bleed_2_3  vw_route_2_3  vss  10000meg
XMN4_r_2_3  vw_route_2_3  we_route  iwrite_route_2_3  vss  sky130_fd_pr__nfet_01v8  w=0.5  l=0.5
X_rhebb_2_3  iwrite_route_2_3  inp_upper_3  ierr_dig_2  vcm_route  vdd vss  hebbian_mult
XMPRED_r_2_4  i_pred_2  vw_route_2_4  vss  vss  sky130_fd_pr__nfet_01v8  w=4  l=0.35
Cw_route_2_4  vw_route_2_4  vss  200f
R_bleed_2_4  vw_route_2_4  vss  10000meg
XMN4_r_2_4  vw_route_2_4  we_route  iwrite_route_2_4  vss  sky130_fd_pr__nfet_01v8  w=0.5  l=0.5
X_rhebb_2_4  iwrite_route_2_4  inp_upper_4  ierr_dig_2  vcm_route  vdd vss  hebbian_mult
XMPRED_r_2_5  i_pred_2  vw_route_2_5  vss  vss  sky130_fd_pr__nfet_01v8  w=4  l=0.35
Cw_route_2_5  vw_route_2_5  vss  200f
R_bleed_2_5  vw_route_2_5  vss  10000meg
XMN4_r_2_5  vw_route_2_5  we_route  iwrite_route_2_5  vss  sky130_fd_pr__nfet_01v8  w=0.5  l=0.5
X_rhebb_2_5  iwrite_route_2_5  inp_upper_5  ierr_dig_2  vcm_route  vdd vss  hebbian_mult
XMPRED_r_2_6  i_pred_2  vw_route_2_6  vss  vss  sky130_fd_pr__nfet_01v8  w=4  l=0.35
Cw_route_2_6  vw_route_2_6  vss  200f
R_bleed_2_6  vw_route_2_6  vss  10000meg
XMN4_r_2_6  vw_route_2_6  we_route  iwrite_route_2_6  vss  sky130_fd_pr__nfet_01v8  w=0.5  l=0.5
X_rhebb_2_6  iwrite_route_2_6  inp_upper_6  ierr_dig_2  vcm_route  vdd vss  hebbian_mult
XMPRED_r_2_7  i_pred_2  vw_route_2_7  vss  vss  sky130_fd_pr__nfet_01v8  w=4  l=0.35
Cw_route_2_7  vw_route_2_7  vss  200f
R_bleed_2_7  vw_route_2_7  vss  10000meg
XMN4_r_2_7  vw_route_2_7  we_route  iwrite_route_2_7  vss  sky130_fd_pr__nfet_01v8  w=0.5  l=0.5
X_rhebb_2_7  iwrite_route_2_7  inp_upper_7  ierr_dig_2  vcm_route  vdd vss  hebbian_mult
XMPRED_r_2_8  i_pred_2  vw_route_2_8  vss  vss  sky130_fd_pr__nfet_01v8  w=4  l=0.35
Cw_route_2_8  vw_route_2_8  vss  200f
R_bleed_2_8  vw_route_2_8  vss  10000meg
XMN4_r_2_8  vw_route_2_8  we_route  iwrite_route_2_8  vss  sky130_fd_pr__nfet_01v8  w=0.5  l=0.5
X_rhebb_2_8  iwrite_route_2_8  inp_upper_8  ierr_dig_2  vcm_route  vdd vss  hebbian_mult
XMPRED_r_2_9  i_pred_2  vw_route_2_9  vss  vss  sky130_fd_pr__nfet_01v8  w=4  l=0.35
Cw_route_2_9  vw_route_2_9  vss  200f
R_bleed_2_9  vw_route_2_9  vss  10000meg
XMN4_r_2_9  vw_route_2_9  we_route  iwrite_route_2_9  vss  sky130_fd_pr__nfet_01v8  w=0.5  l=0.5
X_rhebb_2_9  iwrite_route_2_9  inp_upper_9  ierr_dig_2  vcm_route  vdd vss  hebbian_mult
XMPRED_r_2_10  i_pred_2  vw_route_2_10  vss  vss  sky130_fd_pr__nfet_01v8  w=4  l=0.35
Cw_route_2_10  vw_route_2_10  vss  200f
R_bleed_2_10  vw_route_2_10  vss  10000meg
XMN4_r_2_10  vw_route_2_10  we_route  iwrite_route_2_10  vss  sky130_fd_pr__nfet_01v8  w=0.5  l=0.5
X_rhebb_2_10  iwrite_route_2_10  inp_upper_10  ierr_dig_2  vcm_route  vdd vss  hebbian_mult
XMPRED_r_2_11  i_pred_2  vw_route_2_11  vss  vss  sky130_fd_pr__nfet_01v8  w=4  l=0.35
Cw_route_2_11  vw_route_2_11  vss  200f
R_bleed_2_11  vw_route_2_11  vss  10000meg
XMN4_r_2_11  vw_route_2_11  we_route  iwrite_route_2_11  vss  sky130_fd_pr__nfet_01v8  w=0.5  l=0.5
X_rhebb_2_11  iwrite_route_2_11  inp_upper_11  ierr_dig_2  vcm_route  vdd vss  hebbian_mult
XMPRED_r_2_12  i_pred_2  vw_route_2_12  vss  vss  sky130_fd_pr__nfet_01v8  w=4  l=0.35
Cw_route_2_12  vw_route_2_12  vss  200f
R_bleed_2_12  vw_route_2_12  vss  10000meg
XMN4_r_2_12  vw_route_2_12  we_route  iwrite_route_2_12  vss  sky130_fd_pr__nfet_01v8  w=0.5  l=0.5
X_rhebb_2_12  iwrite_route_2_12  inp_upper_12  ierr_dig_2  vcm_route  vdd vss  hebbian_mult
XMPRED_r_2_13  i_pred_2  vw_route_2_13  vss  vss  sky130_fd_pr__nfet_01v8  w=4  l=0.35
Cw_route_2_13  vw_route_2_13  vss  200f
R_bleed_2_13  vw_route_2_13  vss  10000meg
XMN4_r_2_13  vw_route_2_13  we_route  iwrite_route_2_13  vss  sky130_fd_pr__nfet_01v8  w=0.5  l=0.5
X_rhebb_2_13  iwrite_route_2_13  inp_upper_13  ierr_dig_2  vcm_route  vdd vss  hebbian_mult
XMPRED_r_2_14  i_pred_2  vw_route_2_14  vss  vss  sky130_fd_pr__nfet_01v8  w=4  l=0.35
Cw_route_2_14  vw_route_2_14  vss  200f
R_bleed_2_14  vw_route_2_14  vss  10000meg
XMN4_r_2_14  vw_route_2_14  we_route  iwrite_route_2_14  vss  sky130_fd_pr__nfet_01v8  w=0.5  l=0.5
X_rhebb_2_14  iwrite_route_2_14  inp_upper_14  ierr_dig_2  vcm_route  vdd vss  hebbian_mult
XMPRED_r_2_15  i_pred_2  vw_route_2_15  vss  vss  sky130_fd_pr__nfet_01v8  w=4  l=0.35
Cw_route_2_15  vw_route_2_15  vss  200f
R_bleed_2_15  vw_route_2_15  vss  10000meg
XMN4_r_2_15  vw_route_2_15  we_route  iwrite_route_2_15  vss  sky130_fd_pr__nfet_01v8  w=0.5  l=0.5
X_rhebb_2_15  iwrite_route_2_15  inp_upper_15  ierr_dig_2  vcm_route  vdd vss  hebbian_mult

* ── Destination row 3 ── 16 source connections ──────────────────────────
XMPRED_r_3_0  i_pred_3  vw_route_3_0  vss  vss  sky130_fd_pr__nfet_01v8  w=4  l=0.35
Cw_route_3_0  vw_route_3_0  vss  200f
R_bleed_3_0  vw_route_3_0  vss  10000meg
XMN4_r_3_0  vw_route_3_0  we_route  iwrite_route_3_0  vss  sky130_fd_pr__nfet_01v8  w=0.5  l=0.5
X_rhebb_3_0  iwrite_route_3_0  inp_upper_0  ierr_dig_3  vcm_route  vdd vss  hebbian_mult
XMPRED_r_3_1  i_pred_3  vw_route_3_1  vss  vss  sky130_fd_pr__nfet_01v8  w=4  l=0.35
Cw_route_3_1  vw_route_3_1  vss  200f
R_bleed_3_1  vw_route_3_1  vss  10000meg
XMN4_r_3_1  vw_route_3_1  we_route  iwrite_route_3_1  vss  sky130_fd_pr__nfet_01v8  w=0.5  l=0.5
X_rhebb_3_1  iwrite_route_3_1  inp_upper_1  ierr_dig_3  vcm_route  vdd vss  hebbian_mult
XMPRED_r_3_2  i_pred_3  vw_route_3_2  vss  vss  sky130_fd_pr__nfet_01v8  w=4  l=0.35
Cw_route_3_2  vw_route_3_2  vss  200f
R_bleed_3_2  vw_route_3_2  vss  10000meg
XMN4_r_3_2  vw_route_3_2  we_route  iwrite_route_3_2  vss  sky130_fd_pr__nfet_01v8  w=0.5  l=0.5
X_rhebb_3_2  iwrite_route_3_2  inp_upper_2  ierr_dig_3  vcm_route  vdd vss  hebbian_mult
XMPRED_r_3_3  i_pred_3  vw_route_3_3  vss  vss  sky130_fd_pr__nfet_01v8  w=4  l=0.35
Cw_route_3_3  vw_route_3_3  vss  200f
R_bleed_3_3  vw_route_3_3  vss  10000meg
XMN4_r_3_3  vw_route_3_3  we_route  iwrite_route_3_3  vss  sky130_fd_pr__nfet_01v8  w=0.5  l=0.5
X_rhebb_3_3  iwrite_route_3_3  inp_upper_3  ierr_dig_3  vcm_route  vdd vss  hebbian_mult
XMPRED_r_3_4  i_pred_3  vw_route_3_4  vss  vss  sky130_fd_pr__nfet_01v8  w=4  l=0.35
Cw_route_3_4  vw_route_3_4  vss  200f
R_bleed_3_4  vw_route_3_4  vss  10000meg
XMN4_r_3_4  vw_route_3_4  we_route  iwrite_route_3_4  vss  sky130_fd_pr__nfet_01v8  w=0.5  l=0.5
X_rhebb_3_4  iwrite_route_3_4  inp_upper_4  ierr_dig_3  vcm_route  vdd vss  hebbian_mult
XMPRED_r_3_5  i_pred_3  vw_route_3_5  vss  vss  sky130_fd_pr__nfet_01v8  w=4  l=0.35
Cw_route_3_5  vw_route_3_5  vss  200f
R_bleed_3_5  vw_route_3_5  vss  10000meg
XMN4_r_3_5  vw_route_3_5  we_route  iwrite_route_3_5  vss  sky130_fd_pr__nfet_01v8  w=0.5  l=0.5
X_rhebb_3_5  iwrite_route_3_5  inp_upper_5  ierr_dig_3  vcm_route  vdd vss  hebbian_mult
XMPRED_r_3_6  i_pred_3  vw_route_3_6  vss  vss  sky130_fd_pr__nfet_01v8  w=4  l=0.35
Cw_route_3_6  vw_route_3_6  vss  200f
R_bleed_3_6  vw_route_3_6  vss  10000meg
XMN4_r_3_6  vw_route_3_6  we_route  iwrite_route_3_6  vss  sky130_fd_pr__nfet_01v8  w=0.5  l=0.5
X_rhebb_3_6  iwrite_route_3_6  inp_upper_6  ierr_dig_3  vcm_route  vdd vss  hebbian_mult
XMPRED_r_3_7  i_pred_3  vw_route_3_7  vss  vss  sky130_fd_pr__nfet_01v8  w=4  l=0.35
Cw_route_3_7  vw_route_3_7  vss  200f
R_bleed_3_7  vw_route_3_7  vss  10000meg
XMN4_r_3_7  vw_route_3_7  we_route  iwrite_route_3_7  vss  sky130_fd_pr__nfet_01v8  w=0.5  l=0.5
X_rhebb_3_7  iwrite_route_3_7  inp_upper_7  ierr_dig_3  vcm_route  vdd vss  hebbian_mult
XMPRED_r_3_8  i_pred_3  vw_route_3_8  vss  vss  sky130_fd_pr__nfet_01v8  w=4  l=0.35
Cw_route_3_8  vw_route_3_8  vss  200f
R_bleed_3_8  vw_route_3_8  vss  10000meg
XMN4_r_3_8  vw_route_3_8  we_route  iwrite_route_3_8  vss  sky130_fd_pr__nfet_01v8  w=0.5  l=0.5
X_rhebb_3_8  iwrite_route_3_8  inp_upper_8  ierr_dig_3  vcm_route  vdd vss  hebbian_mult
XMPRED_r_3_9  i_pred_3  vw_route_3_9  vss  vss  sky130_fd_pr__nfet_01v8  w=4  l=0.35
Cw_route_3_9  vw_route_3_9  vss  200f
R_bleed_3_9  vw_route_3_9  vss  10000meg
XMN4_r_3_9  vw_route_3_9  we_route  iwrite_route_3_9  vss  sky130_fd_pr__nfet_01v8  w=0.5  l=0.5
X_rhebb_3_9  iwrite_route_3_9  inp_upper_9  ierr_dig_3  vcm_route  vdd vss  hebbian_mult
XMPRED_r_3_10  i_pred_3  vw_route_3_10  vss  vss  sky130_fd_pr__nfet_01v8  w=4  l=0.35
Cw_route_3_10  vw_route_3_10  vss  200f
R_bleed_3_10  vw_route_3_10  vss  10000meg
XMN4_r_3_10  vw_route_3_10  we_route  iwrite_route_3_10  vss  sky130_fd_pr__nfet_01v8  w=0.5  l=0.5
X_rhebb_3_10  iwrite_route_3_10  inp_upper_10  ierr_dig_3  vcm_route  vdd vss  hebbian_mult
XMPRED_r_3_11  i_pred_3  vw_route_3_11  vss  vss  sky130_fd_pr__nfet_01v8  w=4  l=0.35
Cw_route_3_11  vw_route_3_11  vss  200f
R_bleed_3_11  vw_route_3_11  vss  10000meg
XMN4_r_3_11  vw_route_3_11  we_route  iwrite_route_3_11  vss  sky130_fd_pr__nfet_01v8  w=0.5  l=0.5
X_rhebb_3_11  iwrite_route_3_11  inp_upper_11  ierr_dig_3  vcm_route  vdd vss  hebbian_mult
XMPRED_r_3_12  i_pred_3  vw_route_3_12  vss  vss  sky130_fd_pr__nfet_01v8  w=4  l=0.35
Cw_route_3_12  vw_route_3_12  vss  200f
R_bleed_3_12  vw_route_3_12  vss  10000meg
XMN4_r_3_12  vw_route_3_12  we_route  iwrite_route_3_12  vss  sky130_fd_pr__nfet_01v8  w=0.5  l=0.5
X_rhebb_3_12  iwrite_route_3_12  inp_upper_12  ierr_dig_3  vcm_route  vdd vss  hebbian_mult
XMPRED_r_3_13  i_pred_3  vw_route_3_13  vss  vss  sky130_fd_pr__nfet_01v8  w=4  l=0.35
Cw_route_3_13  vw_route_3_13  vss  200f
R_bleed_3_13  vw_route_3_13  vss  10000meg
XMN4_r_3_13  vw_route_3_13  we_route  iwrite_route_3_13  vss  sky130_fd_pr__nfet_01v8  w=0.5  l=0.5
X_rhebb_3_13  iwrite_route_3_13  inp_upper_13  ierr_dig_3  vcm_route  vdd vss  hebbian_mult
XMPRED_r_3_14  i_pred_3  vw_route_3_14  vss  vss  sky130_fd_pr__nfet_01v8  w=4  l=0.35
Cw_route_3_14  vw_route_3_14  vss  200f
R_bleed_3_14  vw_route_3_14  vss  10000meg
XMN4_r_3_14  vw_route_3_14  we_route  iwrite_route_3_14  vss  sky130_fd_pr__nfet_01v8  w=0.5  l=0.5
X_rhebb_3_14  iwrite_route_3_14  inp_upper_14  ierr_dig_3  vcm_route  vdd vss  hebbian_mult
XMPRED_r_3_15  i_pred_3  vw_route_3_15  vss  vss  sky130_fd_pr__nfet_01v8  w=4  l=0.35
Cw_route_3_15  vw_route_3_15  vss  200f
R_bleed_3_15  vw_route_3_15  vss  10000meg
XMN4_r_3_15  vw_route_3_15  we_route  iwrite_route_3_15  vss  sky130_fd_pr__nfet_01v8  w=0.5  l=0.5
X_rhebb_3_15  iwrite_route_3_15  inp_upper_15  ierr_dig_3  vcm_route  vdd vss  hebbian_mult

* ── Destination row 4 ── 16 source connections ──────────────────────────
XMPRED_r_4_0  i_pred_4  vw_route_4_0  vss  vss  sky130_fd_pr__nfet_01v8  w=4  l=0.35
Cw_route_4_0  vw_route_4_0  vss  200f
R_bleed_4_0  vw_route_4_0  vss  10000meg
XMN4_r_4_0  vw_route_4_0  we_route  iwrite_route_4_0  vss  sky130_fd_pr__nfet_01v8  w=0.5  l=0.5
X_rhebb_4_0  iwrite_route_4_0  inp_upper_0  ierr_dig_4  vcm_route  vdd vss  hebbian_mult
XMPRED_r_4_1  i_pred_4  vw_route_4_1  vss  vss  sky130_fd_pr__nfet_01v8  w=4  l=0.35
Cw_route_4_1  vw_route_4_1  vss  200f
R_bleed_4_1  vw_route_4_1  vss  10000meg
XMN4_r_4_1  vw_route_4_1  we_route  iwrite_route_4_1  vss  sky130_fd_pr__nfet_01v8  w=0.5  l=0.5
X_rhebb_4_1  iwrite_route_4_1  inp_upper_1  ierr_dig_4  vcm_route  vdd vss  hebbian_mult
XMPRED_r_4_2  i_pred_4  vw_route_4_2  vss  vss  sky130_fd_pr__nfet_01v8  w=4  l=0.35
Cw_route_4_2  vw_route_4_2  vss  200f
R_bleed_4_2  vw_route_4_2  vss  10000meg
XMN4_r_4_2  vw_route_4_2  we_route  iwrite_route_4_2  vss  sky130_fd_pr__nfet_01v8  w=0.5  l=0.5
X_rhebb_4_2  iwrite_route_4_2  inp_upper_2  ierr_dig_4  vcm_route  vdd vss  hebbian_mult
XMPRED_r_4_3  i_pred_4  vw_route_4_3  vss  vss  sky130_fd_pr__nfet_01v8  w=4  l=0.35
Cw_route_4_3  vw_route_4_3  vss  200f
R_bleed_4_3  vw_route_4_3  vss  10000meg
XMN4_r_4_3  vw_route_4_3  we_route  iwrite_route_4_3  vss  sky130_fd_pr__nfet_01v8  w=0.5  l=0.5
X_rhebb_4_3  iwrite_route_4_3  inp_upper_3  ierr_dig_4  vcm_route  vdd vss  hebbian_mult
XMPRED_r_4_4  i_pred_4  vw_route_4_4  vss  vss  sky130_fd_pr__nfet_01v8  w=4  l=0.35
Cw_route_4_4  vw_route_4_4  vss  200f
R_bleed_4_4  vw_route_4_4  vss  10000meg
XMN4_r_4_4  vw_route_4_4  we_route  iwrite_route_4_4  vss  sky130_fd_pr__nfet_01v8  w=0.5  l=0.5
X_rhebb_4_4  iwrite_route_4_4  inp_upper_4  ierr_dig_4  vcm_route  vdd vss  hebbian_mult
XMPRED_r_4_5  i_pred_4  vw_route_4_5  vss  vss  sky130_fd_pr__nfet_01v8  w=4  l=0.35
Cw_route_4_5  vw_route_4_5  vss  200f
R_bleed_4_5  vw_route_4_5  vss  10000meg
XMN4_r_4_5  vw_route_4_5  we_route  iwrite_route_4_5  vss  sky130_fd_pr__nfet_01v8  w=0.5  l=0.5
X_rhebb_4_5  iwrite_route_4_5  inp_upper_5  ierr_dig_4  vcm_route  vdd vss  hebbian_mult
XMPRED_r_4_6  i_pred_4  vw_route_4_6  vss  vss  sky130_fd_pr__nfet_01v8  w=4  l=0.35
Cw_route_4_6  vw_route_4_6  vss  200f
R_bleed_4_6  vw_route_4_6  vss  10000meg
XMN4_r_4_6  vw_route_4_6  we_route  iwrite_route_4_6  vss  sky130_fd_pr__nfet_01v8  w=0.5  l=0.5
X_rhebb_4_6  iwrite_route_4_6  inp_upper_6  ierr_dig_4  vcm_route  vdd vss  hebbian_mult
XMPRED_r_4_7  i_pred_4  vw_route_4_7  vss  vss  sky130_fd_pr__nfet_01v8  w=4  l=0.35
Cw_route_4_7  vw_route_4_7  vss  200f
R_bleed_4_7  vw_route_4_7  vss  10000meg
XMN4_r_4_7  vw_route_4_7  we_route  iwrite_route_4_7  vss  sky130_fd_pr__nfet_01v8  w=0.5  l=0.5
X_rhebb_4_7  iwrite_route_4_7  inp_upper_7  ierr_dig_4  vcm_route  vdd vss  hebbian_mult
XMPRED_r_4_8  i_pred_4  vw_route_4_8  vss  vss  sky130_fd_pr__nfet_01v8  w=4  l=0.35
Cw_route_4_8  vw_route_4_8  vss  200f
R_bleed_4_8  vw_route_4_8  vss  10000meg
XMN4_r_4_8  vw_route_4_8  we_route  iwrite_route_4_8  vss  sky130_fd_pr__nfet_01v8  w=0.5  l=0.5
X_rhebb_4_8  iwrite_route_4_8  inp_upper_8  ierr_dig_4  vcm_route  vdd vss  hebbian_mult
XMPRED_r_4_9  i_pred_4  vw_route_4_9  vss  vss  sky130_fd_pr__nfet_01v8  w=4  l=0.35
Cw_route_4_9  vw_route_4_9  vss  200f
R_bleed_4_9  vw_route_4_9  vss  10000meg
XMN4_r_4_9  vw_route_4_9  we_route  iwrite_route_4_9  vss  sky130_fd_pr__nfet_01v8  w=0.5  l=0.5
X_rhebb_4_9  iwrite_route_4_9  inp_upper_9  ierr_dig_4  vcm_route  vdd vss  hebbian_mult
XMPRED_r_4_10  i_pred_4  vw_route_4_10  vss  vss  sky130_fd_pr__nfet_01v8  w=4  l=0.35
Cw_route_4_10  vw_route_4_10  vss  200f
R_bleed_4_10  vw_route_4_10  vss  10000meg
XMN4_r_4_10  vw_route_4_10  we_route  iwrite_route_4_10  vss  sky130_fd_pr__nfet_01v8  w=0.5  l=0.5
X_rhebb_4_10  iwrite_route_4_10  inp_upper_10  ierr_dig_4  vcm_route  vdd vss  hebbian_mult
XMPRED_r_4_11  i_pred_4  vw_route_4_11  vss  vss  sky130_fd_pr__nfet_01v8  w=4  l=0.35
Cw_route_4_11  vw_route_4_11  vss  200f
R_bleed_4_11  vw_route_4_11  vss  10000meg
XMN4_r_4_11  vw_route_4_11  we_route  iwrite_route_4_11  vss  sky130_fd_pr__nfet_01v8  w=0.5  l=0.5
X_rhebb_4_11  iwrite_route_4_11  inp_upper_11  ierr_dig_4  vcm_route  vdd vss  hebbian_mult
XMPRED_r_4_12  i_pred_4  vw_route_4_12  vss  vss  sky130_fd_pr__nfet_01v8  w=4  l=0.35
Cw_route_4_12  vw_route_4_12  vss  200f
R_bleed_4_12  vw_route_4_12  vss  10000meg
XMN4_r_4_12  vw_route_4_12  we_route  iwrite_route_4_12  vss  sky130_fd_pr__nfet_01v8  w=0.5  l=0.5
X_rhebb_4_12  iwrite_route_4_12  inp_upper_12  ierr_dig_4  vcm_route  vdd vss  hebbian_mult
XMPRED_r_4_13  i_pred_4  vw_route_4_13  vss  vss  sky130_fd_pr__nfet_01v8  w=4  l=0.35
Cw_route_4_13  vw_route_4_13  vss  200f
R_bleed_4_13  vw_route_4_13  vss  10000meg
XMN4_r_4_13  vw_route_4_13  we_route  iwrite_route_4_13  vss  sky130_fd_pr__nfet_01v8  w=0.5  l=0.5
X_rhebb_4_13  iwrite_route_4_13  inp_upper_13  ierr_dig_4  vcm_route  vdd vss  hebbian_mult
XMPRED_r_4_14  i_pred_4  vw_route_4_14  vss  vss  sky130_fd_pr__nfet_01v8  w=4  l=0.35
Cw_route_4_14  vw_route_4_14  vss  200f
R_bleed_4_14  vw_route_4_14  vss  10000meg
XMN4_r_4_14  vw_route_4_14  we_route  iwrite_route_4_14  vss  sky130_fd_pr__nfet_01v8  w=0.5  l=0.5
X_rhebb_4_14  iwrite_route_4_14  inp_upper_14  ierr_dig_4  vcm_route  vdd vss  hebbian_mult
XMPRED_r_4_15  i_pred_4  vw_route_4_15  vss  vss  sky130_fd_pr__nfet_01v8  w=4  l=0.35
Cw_route_4_15  vw_route_4_15  vss  200f
R_bleed_4_15  vw_route_4_15  vss  10000meg
XMN4_r_4_15  vw_route_4_15  we_route  iwrite_route_4_15  vss  sky130_fd_pr__nfet_01v8  w=0.5  l=0.5
X_rhebb_4_15  iwrite_route_4_15  inp_upper_15  ierr_dig_4  vcm_route  vdd vss  hebbian_mult

* ── Destination row 5 ── 16 source connections ──────────────────────────
XMPRED_r_5_0  i_pred_5  vw_route_5_0  vss  vss  sky130_fd_pr__nfet_01v8  w=4  l=0.35
Cw_route_5_0  vw_route_5_0  vss  200f
R_bleed_5_0  vw_route_5_0  vss  10000meg
XMN4_r_5_0  vw_route_5_0  we_route  iwrite_route_5_0  vss  sky130_fd_pr__nfet_01v8  w=0.5  l=0.5
X_rhebb_5_0  iwrite_route_5_0  inp_upper_0  ierr_dig_5  vcm_route  vdd vss  hebbian_mult
XMPRED_r_5_1  i_pred_5  vw_route_5_1  vss  vss  sky130_fd_pr__nfet_01v8  w=4  l=0.35
Cw_route_5_1  vw_route_5_1  vss  200f
R_bleed_5_1  vw_route_5_1  vss  10000meg
XMN4_r_5_1  vw_route_5_1  we_route  iwrite_route_5_1  vss  sky130_fd_pr__nfet_01v8  w=0.5  l=0.5
X_rhebb_5_1  iwrite_route_5_1  inp_upper_1  ierr_dig_5  vcm_route  vdd vss  hebbian_mult
XMPRED_r_5_2  i_pred_5  vw_route_5_2  vss  vss  sky130_fd_pr__nfet_01v8  w=4  l=0.35
Cw_route_5_2  vw_route_5_2  vss  200f
R_bleed_5_2  vw_route_5_2  vss  10000meg
XMN4_r_5_2  vw_route_5_2  we_route  iwrite_route_5_2  vss  sky130_fd_pr__nfet_01v8  w=0.5  l=0.5
X_rhebb_5_2  iwrite_route_5_2  inp_upper_2  ierr_dig_5  vcm_route  vdd vss  hebbian_mult
XMPRED_r_5_3  i_pred_5  vw_route_5_3  vss  vss  sky130_fd_pr__nfet_01v8  w=4  l=0.35
Cw_route_5_3  vw_route_5_3  vss  200f
R_bleed_5_3  vw_route_5_3  vss  10000meg
XMN4_r_5_3  vw_route_5_3  we_route  iwrite_route_5_3  vss  sky130_fd_pr__nfet_01v8  w=0.5  l=0.5
X_rhebb_5_3  iwrite_route_5_3  inp_upper_3  ierr_dig_5  vcm_route  vdd vss  hebbian_mult
XMPRED_r_5_4  i_pred_5  vw_route_5_4  vss  vss  sky130_fd_pr__nfet_01v8  w=4  l=0.35
Cw_route_5_4  vw_route_5_4  vss  200f
R_bleed_5_4  vw_route_5_4  vss  10000meg
XMN4_r_5_4  vw_route_5_4  we_route  iwrite_route_5_4  vss  sky130_fd_pr__nfet_01v8  w=0.5  l=0.5
X_rhebb_5_4  iwrite_route_5_4  inp_upper_4  ierr_dig_5  vcm_route  vdd vss  hebbian_mult
XMPRED_r_5_5  i_pred_5  vw_route_5_5  vss  vss  sky130_fd_pr__nfet_01v8  w=4  l=0.35
Cw_route_5_5  vw_route_5_5  vss  200f
R_bleed_5_5  vw_route_5_5  vss  10000meg
XMN4_r_5_5  vw_route_5_5  we_route  iwrite_route_5_5  vss  sky130_fd_pr__nfet_01v8  w=0.5  l=0.5
X_rhebb_5_5  iwrite_route_5_5  inp_upper_5  ierr_dig_5  vcm_route  vdd vss  hebbian_mult
XMPRED_r_5_6  i_pred_5  vw_route_5_6  vss  vss  sky130_fd_pr__nfet_01v8  w=4  l=0.35
Cw_route_5_6  vw_route_5_6  vss  200f
R_bleed_5_6  vw_route_5_6  vss  10000meg
XMN4_r_5_6  vw_route_5_6  we_route  iwrite_route_5_6  vss  sky130_fd_pr__nfet_01v8  w=0.5  l=0.5
X_rhebb_5_6  iwrite_route_5_6  inp_upper_6  ierr_dig_5  vcm_route  vdd vss  hebbian_mult
XMPRED_r_5_7  i_pred_5  vw_route_5_7  vss  vss  sky130_fd_pr__nfet_01v8  w=4  l=0.35
Cw_route_5_7  vw_route_5_7  vss  200f
R_bleed_5_7  vw_route_5_7  vss  10000meg
XMN4_r_5_7  vw_route_5_7  we_route  iwrite_route_5_7  vss  sky130_fd_pr__nfet_01v8  w=0.5  l=0.5
X_rhebb_5_7  iwrite_route_5_7  inp_upper_7  ierr_dig_5  vcm_route  vdd vss  hebbian_mult
XMPRED_r_5_8  i_pred_5  vw_route_5_8  vss  vss  sky130_fd_pr__nfet_01v8  w=4  l=0.35
Cw_route_5_8  vw_route_5_8  vss  200f
R_bleed_5_8  vw_route_5_8  vss  10000meg
XMN4_r_5_8  vw_route_5_8  we_route  iwrite_route_5_8  vss  sky130_fd_pr__nfet_01v8  w=0.5  l=0.5
X_rhebb_5_8  iwrite_route_5_8  inp_upper_8  ierr_dig_5  vcm_route  vdd vss  hebbian_mult
XMPRED_r_5_9  i_pred_5  vw_route_5_9  vss  vss  sky130_fd_pr__nfet_01v8  w=4  l=0.35
Cw_route_5_9  vw_route_5_9  vss  200f
R_bleed_5_9  vw_route_5_9  vss  10000meg
XMN4_r_5_9  vw_route_5_9  we_route  iwrite_route_5_9  vss  sky130_fd_pr__nfet_01v8  w=0.5  l=0.5
X_rhebb_5_9  iwrite_route_5_9  inp_upper_9  ierr_dig_5  vcm_route  vdd vss  hebbian_mult
XMPRED_r_5_10  i_pred_5  vw_route_5_10  vss  vss  sky130_fd_pr__nfet_01v8  w=4  l=0.35
Cw_route_5_10  vw_route_5_10  vss  200f
R_bleed_5_10  vw_route_5_10  vss  10000meg
XMN4_r_5_10  vw_route_5_10  we_route  iwrite_route_5_10  vss  sky130_fd_pr__nfet_01v8  w=0.5  l=0.5
X_rhebb_5_10  iwrite_route_5_10  inp_upper_10  ierr_dig_5  vcm_route  vdd vss  hebbian_mult
XMPRED_r_5_11  i_pred_5  vw_route_5_11  vss  vss  sky130_fd_pr__nfet_01v8  w=4  l=0.35
Cw_route_5_11  vw_route_5_11  vss  200f
R_bleed_5_11  vw_route_5_11  vss  10000meg
XMN4_r_5_11  vw_route_5_11  we_route  iwrite_route_5_11  vss  sky130_fd_pr__nfet_01v8  w=0.5  l=0.5
X_rhebb_5_11  iwrite_route_5_11  inp_upper_11  ierr_dig_5  vcm_route  vdd vss  hebbian_mult
XMPRED_r_5_12  i_pred_5  vw_route_5_12  vss  vss  sky130_fd_pr__nfet_01v8  w=4  l=0.35
Cw_route_5_12  vw_route_5_12  vss  200f
R_bleed_5_12  vw_route_5_12  vss  10000meg
XMN4_r_5_12  vw_route_5_12  we_route  iwrite_route_5_12  vss  sky130_fd_pr__nfet_01v8  w=0.5  l=0.5
X_rhebb_5_12  iwrite_route_5_12  inp_upper_12  ierr_dig_5  vcm_route  vdd vss  hebbian_mult
XMPRED_r_5_13  i_pred_5  vw_route_5_13  vss  vss  sky130_fd_pr__nfet_01v8  w=4  l=0.35
Cw_route_5_13  vw_route_5_13  vss  200f
R_bleed_5_13  vw_route_5_13  vss  10000meg
XMN4_r_5_13  vw_route_5_13  we_route  iwrite_route_5_13  vss  sky130_fd_pr__nfet_01v8  w=0.5  l=0.5
X_rhebb_5_13  iwrite_route_5_13  inp_upper_13  ierr_dig_5  vcm_route  vdd vss  hebbian_mult
XMPRED_r_5_14  i_pred_5  vw_route_5_14  vss  vss  sky130_fd_pr__nfet_01v8  w=4  l=0.35
Cw_route_5_14  vw_route_5_14  vss  200f
R_bleed_5_14  vw_route_5_14  vss  10000meg
XMN4_r_5_14  vw_route_5_14  we_route  iwrite_route_5_14  vss  sky130_fd_pr__nfet_01v8  w=0.5  l=0.5
X_rhebb_5_14  iwrite_route_5_14  inp_upper_14  ierr_dig_5  vcm_route  vdd vss  hebbian_mult
XMPRED_r_5_15  i_pred_5  vw_route_5_15  vss  vss  sky130_fd_pr__nfet_01v8  w=4  l=0.35
Cw_route_5_15  vw_route_5_15  vss  200f
R_bleed_5_15  vw_route_5_15  vss  10000meg
XMN4_r_5_15  vw_route_5_15  we_route  iwrite_route_5_15  vss  sky130_fd_pr__nfet_01v8  w=0.5  l=0.5
X_rhebb_5_15  iwrite_route_5_15  inp_upper_15  ierr_dig_5  vcm_route  vdd vss  hebbian_mult

* ── Destination row 6 ── 16 source connections ──────────────────────────
XMPRED_r_6_0  i_pred_6  vw_route_6_0  vss  vss  sky130_fd_pr__nfet_01v8  w=4  l=0.35
Cw_route_6_0  vw_route_6_0  vss  200f
R_bleed_6_0  vw_route_6_0  vss  10000meg
XMN4_r_6_0  vw_route_6_0  we_route  iwrite_route_6_0  vss  sky130_fd_pr__nfet_01v8  w=0.5  l=0.5
X_rhebb_6_0  iwrite_route_6_0  inp_upper_0  ierr_dig_6  vcm_route  vdd vss  hebbian_mult
XMPRED_r_6_1  i_pred_6  vw_route_6_1  vss  vss  sky130_fd_pr__nfet_01v8  w=4  l=0.35
Cw_route_6_1  vw_route_6_1  vss  200f
R_bleed_6_1  vw_route_6_1  vss  10000meg
XMN4_r_6_1  vw_route_6_1  we_route  iwrite_route_6_1  vss  sky130_fd_pr__nfet_01v8  w=0.5  l=0.5
X_rhebb_6_1  iwrite_route_6_1  inp_upper_1  ierr_dig_6  vcm_route  vdd vss  hebbian_mult
XMPRED_r_6_2  i_pred_6  vw_route_6_2  vss  vss  sky130_fd_pr__nfet_01v8  w=4  l=0.35
Cw_route_6_2  vw_route_6_2  vss  200f
R_bleed_6_2  vw_route_6_2  vss  10000meg
XMN4_r_6_2  vw_route_6_2  we_route  iwrite_route_6_2  vss  sky130_fd_pr__nfet_01v8  w=0.5  l=0.5
X_rhebb_6_2  iwrite_route_6_2  inp_upper_2  ierr_dig_6  vcm_route  vdd vss  hebbian_mult
XMPRED_r_6_3  i_pred_6  vw_route_6_3  vss  vss  sky130_fd_pr__nfet_01v8  w=4  l=0.35
Cw_route_6_3  vw_route_6_3  vss  200f
R_bleed_6_3  vw_route_6_3  vss  10000meg
XMN4_r_6_3  vw_route_6_3  we_route  iwrite_route_6_3  vss  sky130_fd_pr__nfet_01v8  w=0.5  l=0.5
X_rhebb_6_3  iwrite_route_6_3  inp_upper_3  ierr_dig_6  vcm_route  vdd vss  hebbian_mult
XMPRED_r_6_4  i_pred_6  vw_route_6_4  vss  vss  sky130_fd_pr__nfet_01v8  w=4  l=0.35
Cw_route_6_4  vw_route_6_4  vss  200f
R_bleed_6_4  vw_route_6_4  vss  10000meg
XMN4_r_6_4  vw_route_6_4  we_route  iwrite_route_6_4  vss  sky130_fd_pr__nfet_01v8  w=0.5  l=0.5
X_rhebb_6_4  iwrite_route_6_4  inp_upper_4  ierr_dig_6  vcm_route  vdd vss  hebbian_mult
XMPRED_r_6_5  i_pred_6  vw_route_6_5  vss  vss  sky130_fd_pr__nfet_01v8  w=4  l=0.35
Cw_route_6_5  vw_route_6_5  vss  200f
R_bleed_6_5  vw_route_6_5  vss  10000meg
XMN4_r_6_5  vw_route_6_5  we_route  iwrite_route_6_5  vss  sky130_fd_pr__nfet_01v8  w=0.5  l=0.5
X_rhebb_6_5  iwrite_route_6_5  inp_upper_5  ierr_dig_6  vcm_route  vdd vss  hebbian_mult
XMPRED_r_6_6  i_pred_6  vw_route_6_6  vss  vss  sky130_fd_pr__nfet_01v8  w=4  l=0.35
Cw_route_6_6  vw_route_6_6  vss  200f
R_bleed_6_6  vw_route_6_6  vss  10000meg
XMN4_r_6_6  vw_route_6_6  we_route  iwrite_route_6_6  vss  sky130_fd_pr__nfet_01v8  w=0.5  l=0.5
X_rhebb_6_6  iwrite_route_6_6  inp_upper_6  ierr_dig_6  vcm_route  vdd vss  hebbian_mult
XMPRED_r_6_7  i_pred_6  vw_route_6_7  vss  vss  sky130_fd_pr__nfet_01v8  w=4  l=0.35
Cw_route_6_7  vw_route_6_7  vss  200f
R_bleed_6_7  vw_route_6_7  vss  10000meg
XMN4_r_6_7  vw_route_6_7  we_route  iwrite_route_6_7  vss  sky130_fd_pr__nfet_01v8  w=0.5  l=0.5
X_rhebb_6_7  iwrite_route_6_7  inp_upper_7  ierr_dig_6  vcm_route  vdd vss  hebbian_mult
XMPRED_r_6_8  i_pred_6  vw_route_6_8  vss  vss  sky130_fd_pr__nfet_01v8  w=4  l=0.35
Cw_route_6_8  vw_route_6_8  vss  200f
R_bleed_6_8  vw_route_6_8  vss  10000meg
XMN4_r_6_8  vw_route_6_8  we_route  iwrite_route_6_8  vss  sky130_fd_pr__nfet_01v8  w=0.5  l=0.5
X_rhebb_6_8  iwrite_route_6_8  inp_upper_8  ierr_dig_6  vcm_route  vdd vss  hebbian_mult
XMPRED_r_6_9  i_pred_6  vw_route_6_9  vss  vss  sky130_fd_pr__nfet_01v8  w=4  l=0.35
Cw_route_6_9  vw_route_6_9  vss  200f
R_bleed_6_9  vw_route_6_9  vss  10000meg
XMN4_r_6_9  vw_route_6_9  we_route  iwrite_route_6_9  vss  sky130_fd_pr__nfet_01v8  w=0.5  l=0.5
X_rhebb_6_9  iwrite_route_6_9  inp_upper_9  ierr_dig_6  vcm_route  vdd vss  hebbian_mult
XMPRED_r_6_10  i_pred_6  vw_route_6_10  vss  vss  sky130_fd_pr__nfet_01v8  w=4  l=0.35
Cw_route_6_10  vw_route_6_10  vss  200f
R_bleed_6_10  vw_route_6_10  vss  10000meg
XMN4_r_6_10  vw_route_6_10  we_route  iwrite_route_6_10  vss  sky130_fd_pr__nfet_01v8  w=0.5  l=0.5
X_rhebb_6_10  iwrite_route_6_10  inp_upper_10  ierr_dig_6  vcm_route  vdd vss  hebbian_mult
XMPRED_r_6_11  i_pred_6  vw_route_6_11  vss  vss  sky130_fd_pr__nfet_01v8  w=4  l=0.35
Cw_route_6_11  vw_route_6_11  vss  200f
R_bleed_6_11  vw_route_6_11  vss  10000meg
XMN4_r_6_11  vw_route_6_11  we_route  iwrite_route_6_11  vss  sky130_fd_pr__nfet_01v8  w=0.5  l=0.5
X_rhebb_6_11  iwrite_route_6_11  inp_upper_11  ierr_dig_6  vcm_route  vdd vss  hebbian_mult
XMPRED_r_6_12  i_pred_6  vw_route_6_12  vss  vss  sky130_fd_pr__nfet_01v8  w=4  l=0.35
Cw_route_6_12  vw_route_6_12  vss  200f
R_bleed_6_12  vw_route_6_12  vss  10000meg
XMN4_r_6_12  vw_route_6_12  we_route  iwrite_route_6_12  vss  sky130_fd_pr__nfet_01v8  w=0.5  l=0.5
X_rhebb_6_12  iwrite_route_6_12  inp_upper_12  ierr_dig_6  vcm_route  vdd vss  hebbian_mult
XMPRED_r_6_13  i_pred_6  vw_route_6_13  vss  vss  sky130_fd_pr__nfet_01v8  w=4  l=0.35
Cw_route_6_13  vw_route_6_13  vss  200f
R_bleed_6_13  vw_route_6_13  vss  10000meg
XMN4_r_6_13  vw_route_6_13  we_route  iwrite_route_6_13  vss  sky130_fd_pr__nfet_01v8  w=0.5  l=0.5
X_rhebb_6_13  iwrite_route_6_13  inp_upper_13  ierr_dig_6  vcm_route  vdd vss  hebbian_mult
XMPRED_r_6_14  i_pred_6  vw_route_6_14  vss  vss  sky130_fd_pr__nfet_01v8  w=4  l=0.35
Cw_route_6_14  vw_route_6_14  vss  200f
R_bleed_6_14  vw_route_6_14  vss  10000meg
XMN4_r_6_14  vw_route_6_14  we_route  iwrite_route_6_14  vss  sky130_fd_pr__nfet_01v8  w=0.5  l=0.5
X_rhebb_6_14  iwrite_route_6_14  inp_upper_14  ierr_dig_6  vcm_route  vdd vss  hebbian_mult
XMPRED_r_6_15  i_pred_6  vw_route_6_15  vss  vss  sky130_fd_pr__nfet_01v8  w=4  l=0.35
Cw_route_6_15  vw_route_6_15  vss  200f
R_bleed_6_15  vw_route_6_15  vss  10000meg
XMN4_r_6_15  vw_route_6_15  we_route  iwrite_route_6_15  vss  sky130_fd_pr__nfet_01v8  w=0.5  l=0.5
X_rhebb_6_15  iwrite_route_6_15  inp_upper_15  ierr_dig_6  vcm_route  vdd vss  hebbian_mult

* ── Destination row 7 ── 16 source connections ──────────────────────────
XMPRED_r_7_0  i_pred_7  vw_route_7_0  vss  vss  sky130_fd_pr__nfet_01v8  w=4  l=0.35
Cw_route_7_0  vw_route_7_0  vss  200f
R_bleed_7_0  vw_route_7_0  vss  10000meg
XMN4_r_7_0  vw_route_7_0  we_route  iwrite_route_7_0  vss  sky130_fd_pr__nfet_01v8  w=0.5  l=0.5
X_rhebb_7_0  iwrite_route_7_0  inp_upper_0  ierr_dig_7  vcm_route  vdd vss  hebbian_mult
XMPRED_r_7_1  i_pred_7  vw_route_7_1  vss  vss  sky130_fd_pr__nfet_01v8  w=4  l=0.35
Cw_route_7_1  vw_route_7_1  vss  200f
R_bleed_7_1  vw_route_7_1  vss  10000meg
XMN4_r_7_1  vw_route_7_1  we_route  iwrite_route_7_1  vss  sky130_fd_pr__nfet_01v8  w=0.5  l=0.5
X_rhebb_7_1  iwrite_route_7_1  inp_upper_1  ierr_dig_7  vcm_route  vdd vss  hebbian_mult
XMPRED_r_7_2  i_pred_7  vw_route_7_2  vss  vss  sky130_fd_pr__nfet_01v8  w=4  l=0.35
Cw_route_7_2  vw_route_7_2  vss  200f
R_bleed_7_2  vw_route_7_2  vss  10000meg
XMN4_r_7_2  vw_route_7_2  we_route  iwrite_route_7_2  vss  sky130_fd_pr__nfet_01v8  w=0.5  l=0.5
X_rhebb_7_2  iwrite_route_7_2  inp_upper_2  ierr_dig_7  vcm_route  vdd vss  hebbian_mult
XMPRED_r_7_3  i_pred_7  vw_route_7_3  vss  vss  sky130_fd_pr__nfet_01v8  w=4  l=0.35
Cw_route_7_3  vw_route_7_3  vss  200f
R_bleed_7_3  vw_route_7_3  vss  10000meg
XMN4_r_7_3  vw_route_7_3  we_route  iwrite_route_7_3  vss  sky130_fd_pr__nfet_01v8  w=0.5  l=0.5
X_rhebb_7_3  iwrite_route_7_3  inp_upper_3  ierr_dig_7  vcm_route  vdd vss  hebbian_mult
XMPRED_r_7_4  i_pred_7  vw_route_7_4  vss  vss  sky130_fd_pr__nfet_01v8  w=4  l=0.35
Cw_route_7_4  vw_route_7_4  vss  200f
R_bleed_7_4  vw_route_7_4  vss  10000meg
XMN4_r_7_4  vw_route_7_4  we_route  iwrite_route_7_4  vss  sky130_fd_pr__nfet_01v8  w=0.5  l=0.5
X_rhebb_7_4  iwrite_route_7_4  inp_upper_4  ierr_dig_7  vcm_route  vdd vss  hebbian_mult
XMPRED_r_7_5  i_pred_7  vw_route_7_5  vss  vss  sky130_fd_pr__nfet_01v8  w=4  l=0.35
Cw_route_7_5  vw_route_7_5  vss  200f
R_bleed_7_5  vw_route_7_5  vss  10000meg
XMN4_r_7_5  vw_route_7_5  we_route  iwrite_route_7_5  vss  sky130_fd_pr__nfet_01v8  w=0.5  l=0.5
X_rhebb_7_5  iwrite_route_7_5  inp_upper_5  ierr_dig_7  vcm_route  vdd vss  hebbian_mult
XMPRED_r_7_6  i_pred_7  vw_route_7_6  vss  vss  sky130_fd_pr__nfet_01v8  w=4  l=0.35
Cw_route_7_6  vw_route_7_6  vss  200f
R_bleed_7_6  vw_route_7_6  vss  10000meg
XMN4_r_7_6  vw_route_7_6  we_route  iwrite_route_7_6  vss  sky130_fd_pr__nfet_01v8  w=0.5  l=0.5
X_rhebb_7_6  iwrite_route_7_6  inp_upper_6  ierr_dig_7  vcm_route  vdd vss  hebbian_mult
XMPRED_r_7_7  i_pred_7  vw_route_7_7  vss  vss  sky130_fd_pr__nfet_01v8  w=4  l=0.35
Cw_route_7_7  vw_route_7_7  vss  200f
R_bleed_7_7  vw_route_7_7  vss  10000meg
XMN4_r_7_7  vw_route_7_7  we_route  iwrite_route_7_7  vss  sky130_fd_pr__nfet_01v8  w=0.5  l=0.5
X_rhebb_7_7  iwrite_route_7_7  inp_upper_7  ierr_dig_7  vcm_route  vdd vss  hebbian_mult
XMPRED_r_7_8  i_pred_7  vw_route_7_8  vss  vss  sky130_fd_pr__nfet_01v8  w=4  l=0.35
Cw_route_7_8  vw_route_7_8  vss  200f
R_bleed_7_8  vw_route_7_8  vss  10000meg
XMN4_r_7_8  vw_route_7_8  we_route  iwrite_route_7_8  vss  sky130_fd_pr__nfet_01v8  w=0.5  l=0.5
X_rhebb_7_8  iwrite_route_7_8  inp_upper_8  ierr_dig_7  vcm_route  vdd vss  hebbian_mult
XMPRED_r_7_9  i_pred_7  vw_route_7_9  vss  vss  sky130_fd_pr__nfet_01v8  w=4  l=0.35
Cw_route_7_9  vw_route_7_9  vss  200f
R_bleed_7_9  vw_route_7_9  vss  10000meg
XMN4_r_7_9  vw_route_7_9  we_route  iwrite_route_7_9  vss  sky130_fd_pr__nfet_01v8  w=0.5  l=0.5
X_rhebb_7_9  iwrite_route_7_9  inp_upper_9  ierr_dig_7  vcm_route  vdd vss  hebbian_mult
XMPRED_r_7_10  i_pred_7  vw_route_7_10  vss  vss  sky130_fd_pr__nfet_01v8  w=4  l=0.35
Cw_route_7_10  vw_route_7_10  vss  200f
R_bleed_7_10  vw_route_7_10  vss  10000meg
XMN4_r_7_10  vw_route_7_10  we_route  iwrite_route_7_10  vss  sky130_fd_pr__nfet_01v8  w=0.5  l=0.5
X_rhebb_7_10  iwrite_route_7_10  inp_upper_10  ierr_dig_7  vcm_route  vdd vss  hebbian_mult
XMPRED_r_7_11  i_pred_7  vw_route_7_11  vss  vss  sky130_fd_pr__nfet_01v8  w=4  l=0.35
Cw_route_7_11  vw_route_7_11  vss  200f
R_bleed_7_11  vw_route_7_11  vss  10000meg
XMN4_r_7_11  vw_route_7_11  we_route  iwrite_route_7_11  vss  sky130_fd_pr__nfet_01v8  w=0.5  l=0.5
X_rhebb_7_11  iwrite_route_7_11  inp_upper_11  ierr_dig_7  vcm_route  vdd vss  hebbian_mult
XMPRED_r_7_12  i_pred_7  vw_route_7_12  vss  vss  sky130_fd_pr__nfet_01v8  w=4  l=0.35
Cw_route_7_12  vw_route_7_12  vss  200f
R_bleed_7_12  vw_route_7_12  vss  10000meg
XMN4_r_7_12  vw_route_7_12  we_route  iwrite_route_7_12  vss  sky130_fd_pr__nfet_01v8  w=0.5  l=0.5
X_rhebb_7_12  iwrite_route_7_12  inp_upper_12  ierr_dig_7  vcm_route  vdd vss  hebbian_mult
XMPRED_r_7_13  i_pred_7  vw_route_7_13  vss  vss  sky130_fd_pr__nfet_01v8  w=4  l=0.35
Cw_route_7_13  vw_route_7_13  vss  200f
R_bleed_7_13  vw_route_7_13  vss  10000meg
XMN4_r_7_13  vw_route_7_13  we_route  iwrite_route_7_13  vss  sky130_fd_pr__nfet_01v8  w=0.5  l=0.5
X_rhebb_7_13  iwrite_route_7_13  inp_upper_13  ierr_dig_7  vcm_route  vdd vss  hebbian_mult
XMPRED_r_7_14  i_pred_7  vw_route_7_14  vss  vss  sky130_fd_pr__nfet_01v8  w=4  l=0.35
Cw_route_7_14  vw_route_7_14  vss  200f
R_bleed_7_14  vw_route_7_14  vss  10000meg
XMN4_r_7_14  vw_route_7_14  we_route  iwrite_route_7_14  vss  sky130_fd_pr__nfet_01v8  w=0.5  l=0.5
X_rhebb_7_14  iwrite_route_7_14  inp_upper_14  ierr_dig_7  vcm_route  vdd vss  hebbian_mult
XMPRED_r_7_15  i_pred_7  vw_route_7_15  vss  vss  sky130_fd_pr__nfet_01v8  w=4  l=0.35
Cw_route_7_15  vw_route_7_15  vss  200f
R_bleed_7_15  vw_route_7_15  vss  10000meg
XMN4_r_7_15  vw_route_7_15  we_route  iwrite_route_7_15  vss  sky130_fd_pr__nfet_01v8  w=0.5  l=0.5
X_rhebb_7_15  iwrite_route_7_15  inp_upper_15  ierr_dig_7  vcm_route  vdd vss  hebbian_mult

* ── Destination row 8 ── 16 source connections ──────────────────────────
XMPRED_r_8_0  i_pred_8  vw_route_8_0  vss  vss  sky130_fd_pr__nfet_01v8  w=4  l=0.35
Cw_route_8_0  vw_route_8_0  vss  200f
R_bleed_8_0  vw_route_8_0  vss  10000meg
XMN4_r_8_0  vw_route_8_0  we_route  iwrite_route_8_0  vss  sky130_fd_pr__nfet_01v8  w=0.5  l=0.5
X_rhebb_8_0  iwrite_route_8_0  inp_upper_0  ierr_dig_8  vcm_route  vdd vss  hebbian_mult
XMPRED_r_8_1  i_pred_8  vw_route_8_1  vss  vss  sky130_fd_pr__nfet_01v8  w=4  l=0.35
Cw_route_8_1  vw_route_8_1  vss  200f
R_bleed_8_1  vw_route_8_1  vss  10000meg
XMN4_r_8_1  vw_route_8_1  we_route  iwrite_route_8_1  vss  sky130_fd_pr__nfet_01v8  w=0.5  l=0.5
X_rhebb_8_1  iwrite_route_8_1  inp_upper_1  ierr_dig_8  vcm_route  vdd vss  hebbian_mult
XMPRED_r_8_2  i_pred_8  vw_route_8_2  vss  vss  sky130_fd_pr__nfet_01v8  w=4  l=0.35
Cw_route_8_2  vw_route_8_2  vss  200f
R_bleed_8_2  vw_route_8_2  vss  10000meg
XMN4_r_8_2  vw_route_8_2  we_route  iwrite_route_8_2  vss  sky130_fd_pr__nfet_01v8  w=0.5  l=0.5
X_rhebb_8_2  iwrite_route_8_2  inp_upper_2  ierr_dig_8  vcm_route  vdd vss  hebbian_mult
XMPRED_r_8_3  i_pred_8  vw_route_8_3  vss  vss  sky130_fd_pr__nfet_01v8  w=4  l=0.35
Cw_route_8_3  vw_route_8_3  vss  200f
R_bleed_8_3  vw_route_8_3  vss  10000meg
XMN4_r_8_3  vw_route_8_3  we_route  iwrite_route_8_3  vss  sky130_fd_pr__nfet_01v8  w=0.5  l=0.5
X_rhebb_8_3  iwrite_route_8_3  inp_upper_3  ierr_dig_8  vcm_route  vdd vss  hebbian_mult
XMPRED_r_8_4  i_pred_8  vw_route_8_4  vss  vss  sky130_fd_pr__nfet_01v8  w=4  l=0.35
Cw_route_8_4  vw_route_8_4  vss  200f
R_bleed_8_4  vw_route_8_4  vss  10000meg
XMN4_r_8_4  vw_route_8_4  we_route  iwrite_route_8_4  vss  sky130_fd_pr__nfet_01v8  w=0.5  l=0.5
X_rhebb_8_4  iwrite_route_8_4  inp_upper_4  ierr_dig_8  vcm_route  vdd vss  hebbian_mult
XMPRED_r_8_5  i_pred_8  vw_route_8_5  vss  vss  sky130_fd_pr__nfet_01v8  w=4  l=0.35
Cw_route_8_5  vw_route_8_5  vss  200f
R_bleed_8_5  vw_route_8_5  vss  10000meg
XMN4_r_8_5  vw_route_8_5  we_route  iwrite_route_8_5  vss  sky130_fd_pr__nfet_01v8  w=0.5  l=0.5
X_rhebb_8_5  iwrite_route_8_5  inp_upper_5  ierr_dig_8  vcm_route  vdd vss  hebbian_mult
XMPRED_r_8_6  i_pred_8  vw_route_8_6  vss  vss  sky130_fd_pr__nfet_01v8  w=4  l=0.35
Cw_route_8_6  vw_route_8_6  vss  200f
R_bleed_8_6  vw_route_8_6  vss  10000meg
XMN4_r_8_6  vw_route_8_6  we_route  iwrite_route_8_6  vss  sky130_fd_pr__nfet_01v8  w=0.5  l=0.5
X_rhebb_8_6  iwrite_route_8_6  inp_upper_6  ierr_dig_8  vcm_route  vdd vss  hebbian_mult
XMPRED_r_8_7  i_pred_8  vw_route_8_7  vss  vss  sky130_fd_pr__nfet_01v8  w=4  l=0.35
Cw_route_8_7  vw_route_8_7  vss  200f
R_bleed_8_7  vw_route_8_7  vss  10000meg
XMN4_r_8_7  vw_route_8_7  we_route  iwrite_route_8_7  vss  sky130_fd_pr__nfet_01v8  w=0.5  l=0.5
X_rhebb_8_7  iwrite_route_8_7  inp_upper_7  ierr_dig_8  vcm_route  vdd vss  hebbian_mult
XMPRED_r_8_8  i_pred_8  vw_route_8_8  vss  vss  sky130_fd_pr__nfet_01v8  w=4  l=0.35
Cw_route_8_8  vw_route_8_8  vss  200f
R_bleed_8_8  vw_route_8_8  vss  10000meg
XMN4_r_8_8  vw_route_8_8  we_route  iwrite_route_8_8  vss  sky130_fd_pr__nfet_01v8  w=0.5  l=0.5
X_rhebb_8_8  iwrite_route_8_8  inp_upper_8  ierr_dig_8  vcm_route  vdd vss  hebbian_mult
XMPRED_r_8_9  i_pred_8  vw_route_8_9  vss  vss  sky130_fd_pr__nfet_01v8  w=4  l=0.35
Cw_route_8_9  vw_route_8_9  vss  200f
R_bleed_8_9  vw_route_8_9  vss  10000meg
XMN4_r_8_9  vw_route_8_9  we_route  iwrite_route_8_9  vss  sky130_fd_pr__nfet_01v8  w=0.5  l=0.5
X_rhebb_8_9  iwrite_route_8_9  inp_upper_9  ierr_dig_8  vcm_route  vdd vss  hebbian_mult
XMPRED_r_8_10  i_pred_8  vw_route_8_10  vss  vss  sky130_fd_pr__nfet_01v8  w=4  l=0.35
Cw_route_8_10  vw_route_8_10  vss  200f
R_bleed_8_10  vw_route_8_10  vss  10000meg
XMN4_r_8_10  vw_route_8_10  we_route  iwrite_route_8_10  vss  sky130_fd_pr__nfet_01v8  w=0.5  l=0.5
X_rhebb_8_10  iwrite_route_8_10  inp_upper_10  ierr_dig_8  vcm_route  vdd vss  hebbian_mult
XMPRED_r_8_11  i_pred_8  vw_route_8_11  vss  vss  sky130_fd_pr__nfet_01v8  w=4  l=0.35
Cw_route_8_11  vw_route_8_11  vss  200f
R_bleed_8_11  vw_route_8_11  vss  10000meg
XMN4_r_8_11  vw_route_8_11  we_route  iwrite_route_8_11  vss  sky130_fd_pr__nfet_01v8  w=0.5  l=0.5
X_rhebb_8_11  iwrite_route_8_11  inp_upper_11  ierr_dig_8  vcm_route  vdd vss  hebbian_mult
XMPRED_r_8_12  i_pred_8  vw_route_8_12  vss  vss  sky130_fd_pr__nfet_01v8  w=4  l=0.35
Cw_route_8_12  vw_route_8_12  vss  200f
R_bleed_8_12  vw_route_8_12  vss  10000meg
XMN4_r_8_12  vw_route_8_12  we_route  iwrite_route_8_12  vss  sky130_fd_pr__nfet_01v8  w=0.5  l=0.5
X_rhebb_8_12  iwrite_route_8_12  inp_upper_12  ierr_dig_8  vcm_route  vdd vss  hebbian_mult
XMPRED_r_8_13  i_pred_8  vw_route_8_13  vss  vss  sky130_fd_pr__nfet_01v8  w=4  l=0.35
Cw_route_8_13  vw_route_8_13  vss  200f
R_bleed_8_13  vw_route_8_13  vss  10000meg
XMN4_r_8_13  vw_route_8_13  we_route  iwrite_route_8_13  vss  sky130_fd_pr__nfet_01v8  w=0.5  l=0.5
X_rhebb_8_13  iwrite_route_8_13  inp_upper_13  ierr_dig_8  vcm_route  vdd vss  hebbian_mult
XMPRED_r_8_14  i_pred_8  vw_route_8_14  vss  vss  sky130_fd_pr__nfet_01v8  w=4  l=0.35
Cw_route_8_14  vw_route_8_14  vss  200f
R_bleed_8_14  vw_route_8_14  vss  10000meg
XMN4_r_8_14  vw_route_8_14  we_route  iwrite_route_8_14  vss  sky130_fd_pr__nfet_01v8  w=0.5  l=0.5
X_rhebb_8_14  iwrite_route_8_14  inp_upper_14  ierr_dig_8  vcm_route  vdd vss  hebbian_mult
XMPRED_r_8_15  i_pred_8  vw_route_8_15  vss  vss  sky130_fd_pr__nfet_01v8  w=4  l=0.35
Cw_route_8_15  vw_route_8_15  vss  200f
R_bleed_8_15  vw_route_8_15  vss  10000meg
XMN4_r_8_15  vw_route_8_15  we_route  iwrite_route_8_15  vss  sky130_fd_pr__nfet_01v8  w=0.5  l=0.5
X_rhebb_8_15  iwrite_route_8_15  inp_upper_15  ierr_dig_8  vcm_route  vdd vss  hebbian_mult

* ── Destination row 9 ── 16 source connections ──────────────────────────
XMPRED_r_9_0  i_pred_9  vw_route_9_0  vss  vss  sky130_fd_pr__nfet_01v8  w=4  l=0.35
Cw_route_9_0  vw_route_9_0  vss  200f
R_bleed_9_0  vw_route_9_0  vss  10000meg
XMN4_r_9_0  vw_route_9_0  we_route  iwrite_route_9_0  vss  sky130_fd_pr__nfet_01v8  w=0.5  l=0.5
X_rhebb_9_0  iwrite_route_9_0  inp_upper_0  ierr_dig_9  vcm_route  vdd vss  hebbian_mult
XMPRED_r_9_1  i_pred_9  vw_route_9_1  vss  vss  sky130_fd_pr__nfet_01v8  w=4  l=0.35
Cw_route_9_1  vw_route_9_1  vss  200f
R_bleed_9_1  vw_route_9_1  vss  10000meg
XMN4_r_9_1  vw_route_9_1  we_route  iwrite_route_9_1  vss  sky130_fd_pr__nfet_01v8  w=0.5  l=0.5
X_rhebb_9_1  iwrite_route_9_1  inp_upper_1  ierr_dig_9  vcm_route  vdd vss  hebbian_mult
XMPRED_r_9_2  i_pred_9  vw_route_9_2  vss  vss  sky130_fd_pr__nfet_01v8  w=4  l=0.35
Cw_route_9_2  vw_route_9_2  vss  200f
R_bleed_9_2  vw_route_9_2  vss  10000meg
XMN4_r_9_2  vw_route_9_2  we_route  iwrite_route_9_2  vss  sky130_fd_pr__nfet_01v8  w=0.5  l=0.5
X_rhebb_9_2  iwrite_route_9_2  inp_upper_2  ierr_dig_9  vcm_route  vdd vss  hebbian_mult
XMPRED_r_9_3  i_pred_9  vw_route_9_3  vss  vss  sky130_fd_pr__nfet_01v8  w=4  l=0.35
Cw_route_9_3  vw_route_9_3  vss  200f
R_bleed_9_3  vw_route_9_3  vss  10000meg
XMN4_r_9_3  vw_route_9_3  we_route  iwrite_route_9_3  vss  sky130_fd_pr__nfet_01v8  w=0.5  l=0.5
X_rhebb_9_3  iwrite_route_9_3  inp_upper_3  ierr_dig_9  vcm_route  vdd vss  hebbian_mult
XMPRED_r_9_4  i_pred_9  vw_route_9_4  vss  vss  sky130_fd_pr__nfet_01v8  w=4  l=0.35
Cw_route_9_4  vw_route_9_4  vss  200f
R_bleed_9_4  vw_route_9_4  vss  10000meg
XMN4_r_9_4  vw_route_9_4  we_route  iwrite_route_9_4  vss  sky130_fd_pr__nfet_01v8  w=0.5  l=0.5
X_rhebb_9_4  iwrite_route_9_4  inp_upper_4  ierr_dig_9  vcm_route  vdd vss  hebbian_mult
XMPRED_r_9_5  i_pred_9  vw_route_9_5  vss  vss  sky130_fd_pr__nfet_01v8  w=4  l=0.35
Cw_route_9_5  vw_route_9_5  vss  200f
R_bleed_9_5  vw_route_9_5  vss  10000meg
XMN4_r_9_5  vw_route_9_5  we_route  iwrite_route_9_5  vss  sky130_fd_pr__nfet_01v8  w=0.5  l=0.5
X_rhebb_9_5  iwrite_route_9_5  inp_upper_5  ierr_dig_9  vcm_route  vdd vss  hebbian_mult
XMPRED_r_9_6  i_pred_9  vw_route_9_6  vss  vss  sky130_fd_pr__nfet_01v8  w=4  l=0.35
Cw_route_9_6  vw_route_9_6  vss  200f
R_bleed_9_6  vw_route_9_6  vss  10000meg
XMN4_r_9_6  vw_route_9_6  we_route  iwrite_route_9_6  vss  sky130_fd_pr__nfet_01v8  w=0.5  l=0.5
X_rhebb_9_6  iwrite_route_9_6  inp_upper_6  ierr_dig_9  vcm_route  vdd vss  hebbian_mult
XMPRED_r_9_7  i_pred_9  vw_route_9_7  vss  vss  sky130_fd_pr__nfet_01v8  w=4  l=0.35
Cw_route_9_7  vw_route_9_7  vss  200f
R_bleed_9_7  vw_route_9_7  vss  10000meg
XMN4_r_9_7  vw_route_9_7  we_route  iwrite_route_9_7  vss  sky130_fd_pr__nfet_01v8  w=0.5  l=0.5
X_rhebb_9_7  iwrite_route_9_7  inp_upper_7  ierr_dig_9  vcm_route  vdd vss  hebbian_mult
XMPRED_r_9_8  i_pred_9  vw_route_9_8  vss  vss  sky130_fd_pr__nfet_01v8  w=4  l=0.35
Cw_route_9_8  vw_route_9_8  vss  200f
R_bleed_9_8  vw_route_9_8  vss  10000meg
XMN4_r_9_8  vw_route_9_8  we_route  iwrite_route_9_8  vss  sky130_fd_pr__nfet_01v8  w=0.5  l=0.5
X_rhebb_9_8  iwrite_route_9_8  inp_upper_8  ierr_dig_9  vcm_route  vdd vss  hebbian_mult
XMPRED_r_9_9  i_pred_9  vw_route_9_9  vss  vss  sky130_fd_pr__nfet_01v8  w=4  l=0.35
Cw_route_9_9  vw_route_9_9  vss  200f
R_bleed_9_9  vw_route_9_9  vss  10000meg
XMN4_r_9_9  vw_route_9_9  we_route  iwrite_route_9_9  vss  sky130_fd_pr__nfet_01v8  w=0.5  l=0.5
X_rhebb_9_9  iwrite_route_9_9  inp_upper_9  ierr_dig_9  vcm_route  vdd vss  hebbian_mult
XMPRED_r_9_10  i_pred_9  vw_route_9_10  vss  vss  sky130_fd_pr__nfet_01v8  w=4  l=0.35
Cw_route_9_10  vw_route_9_10  vss  200f
R_bleed_9_10  vw_route_9_10  vss  10000meg
XMN4_r_9_10  vw_route_9_10  we_route  iwrite_route_9_10  vss  sky130_fd_pr__nfet_01v8  w=0.5  l=0.5
X_rhebb_9_10  iwrite_route_9_10  inp_upper_10  ierr_dig_9  vcm_route  vdd vss  hebbian_mult
XMPRED_r_9_11  i_pred_9  vw_route_9_11  vss  vss  sky130_fd_pr__nfet_01v8  w=4  l=0.35
Cw_route_9_11  vw_route_9_11  vss  200f
R_bleed_9_11  vw_route_9_11  vss  10000meg
XMN4_r_9_11  vw_route_9_11  we_route  iwrite_route_9_11  vss  sky130_fd_pr__nfet_01v8  w=0.5  l=0.5
X_rhebb_9_11  iwrite_route_9_11  inp_upper_11  ierr_dig_9  vcm_route  vdd vss  hebbian_mult
XMPRED_r_9_12  i_pred_9  vw_route_9_12  vss  vss  sky130_fd_pr__nfet_01v8  w=4  l=0.35
Cw_route_9_12  vw_route_9_12  vss  200f
R_bleed_9_12  vw_route_9_12  vss  10000meg
XMN4_r_9_12  vw_route_9_12  we_route  iwrite_route_9_12  vss  sky130_fd_pr__nfet_01v8  w=0.5  l=0.5
X_rhebb_9_12  iwrite_route_9_12  inp_upper_12  ierr_dig_9  vcm_route  vdd vss  hebbian_mult
XMPRED_r_9_13  i_pred_9  vw_route_9_13  vss  vss  sky130_fd_pr__nfet_01v8  w=4  l=0.35
Cw_route_9_13  vw_route_9_13  vss  200f
R_bleed_9_13  vw_route_9_13  vss  10000meg
XMN4_r_9_13  vw_route_9_13  we_route  iwrite_route_9_13  vss  sky130_fd_pr__nfet_01v8  w=0.5  l=0.5
X_rhebb_9_13  iwrite_route_9_13  inp_upper_13  ierr_dig_9  vcm_route  vdd vss  hebbian_mult
XMPRED_r_9_14  i_pred_9  vw_route_9_14  vss  vss  sky130_fd_pr__nfet_01v8  w=4  l=0.35
Cw_route_9_14  vw_route_9_14  vss  200f
R_bleed_9_14  vw_route_9_14  vss  10000meg
XMN4_r_9_14  vw_route_9_14  we_route  iwrite_route_9_14  vss  sky130_fd_pr__nfet_01v8  w=0.5  l=0.5
X_rhebb_9_14  iwrite_route_9_14  inp_upper_14  ierr_dig_9  vcm_route  vdd vss  hebbian_mult
XMPRED_r_9_15  i_pred_9  vw_route_9_15  vss  vss  sky130_fd_pr__nfet_01v8  w=4  l=0.35
Cw_route_9_15  vw_route_9_15  vss  200f
R_bleed_9_15  vw_route_9_15  vss  10000meg
XMN4_r_9_15  vw_route_9_15  we_route  iwrite_route_9_15  vss  sky130_fd_pr__nfet_01v8  w=0.5  l=0.5
X_rhebb_9_15  iwrite_route_9_15  inp_upper_15  ierr_dig_9  vcm_route  vdd vss  hebbian_mult

* ── Destination row 10 ── 16 source connections ──────────────────────────
XMPRED_r_10_0  i_pred_10  vw_route_10_0  vss  vss  sky130_fd_pr__nfet_01v8  w=4  l=0.35
Cw_route_10_0  vw_route_10_0  vss  200f
R_bleed_10_0  vw_route_10_0  vss  10000meg
XMN4_r_10_0  vw_route_10_0  we_route  iwrite_route_10_0  vss  sky130_fd_pr__nfet_01v8  w=0.5  l=0.5
X_rhebb_10_0  iwrite_route_10_0  inp_upper_0  ierr_dig_10  vcm_route  vdd vss  hebbian_mult
XMPRED_r_10_1  i_pred_10  vw_route_10_1  vss  vss  sky130_fd_pr__nfet_01v8  w=4  l=0.35
Cw_route_10_1  vw_route_10_1  vss  200f
R_bleed_10_1  vw_route_10_1  vss  10000meg
XMN4_r_10_1  vw_route_10_1  we_route  iwrite_route_10_1  vss  sky130_fd_pr__nfet_01v8  w=0.5  l=0.5
X_rhebb_10_1  iwrite_route_10_1  inp_upper_1  ierr_dig_10  vcm_route  vdd vss  hebbian_mult
XMPRED_r_10_2  i_pred_10  vw_route_10_2  vss  vss  sky130_fd_pr__nfet_01v8  w=4  l=0.35
Cw_route_10_2  vw_route_10_2  vss  200f
R_bleed_10_2  vw_route_10_2  vss  10000meg
XMN4_r_10_2  vw_route_10_2  we_route  iwrite_route_10_2  vss  sky130_fd_pr__nfet_01v8  w=0.5  l=0.5
X_rhebb_10_2  iwrite_route_10_2  inp_upper_2  ierr_dig_10  vcm_route  vdd vss  hebbian_mult
XMPRED_r_10_3  i_pred_10  vw_route_10_3  vss  vss  sky130_fd_pr__nfet_01v8  w=4  l=0.35
Cw_route_10_3  vw_route_10_3  vss  200f
R_bleed_10_3  vw_route_10_3  vss  10000meg
XMN4_r_10_3  vw_route_10_3  we_route  iwrite_route_10_3  vss  sky130_fd_pr__nfet_01v8  w=0.5  l=0.5
X_rhebb_10_3  iwrite_route_10_3  inp_upper_3  ierr_dig_10  vcm_route  vdd vss  hebbian_mult
XMPRED_r_10_4  i_pred_10  vw_route_10_4  vss  vss  sky130_fd_pr__nfet_01v8  w=4  l=0.35
Cw_route_10_4  vw_route_10_4  vss  200f
R_bleed_10_4  vw_route_10_4  vss  10000meg
XMN4_r_10_4  vw_route_10_4  we_route  iwrite_route_10_4  vss  sky130_fd_pr__nfet_01v8  w=0.5  l=0.5
X_rhebb_10_4  iwrite_route_10_4  inp_upper_4  ierr_dig_10  vcm_route  vdd vss  hebbian_mult
XMPRED_r_10_5  i_pred_10  vw_route_10_5  vss  vss  sky130_fd_pr__nfet_01v8  w=4  l=0.35
Cw_route_10_5  vw_route_10_5  vss  200f
R_bleed_10_5  vw_route_10_5  vss  10000meg
XMN4_r_10_5  vw_route_10_5  we_route  iwrite_route_10_5  vss  sky130_fd_pr__nfet_01v8  w=0.5  l=0.5
X_rhebb_10_5  iwrite_route_10_5  inp_upper_5  ierr_dig_10  vcm_route  vdd vss  hebbian_mult
XMPRED_r_10_6  i_pred_10  vw_route_10_6  vss  vss  sky130_fd_pr__nfet_01v8  w=4  l=0.35
Cw_route_10_6  vw_route_10_6  vss  200f
R_bleed_10_6  vw_route_10_6  vss  10000meg
XMN4_r_10_6  vw_route_10_6  we_route  iwrite_route_10_6  vss  sky130_fd_pr__nfet_01v8  w=0.5  l=0.5
X_rhebb_10_6  iwrite_route_10_6  inp_upper_6  ierr_dig_10  vcm_route  vdd vss  hebbian_mult
XMPRED_r_10_7  i_pred_10  vw_route_10_7  vss  vss  sky130_fd_pr__nfet_01v8  w=4  l=0.35
Cw_route_10_7  vw_route_10_7  vss  200f
R_bleed_10_7  vw_route_10_7  vss  10000meg
XMN4_r_10_7  vw_route_10_7  we_route  iwrite_route_10_7  vss  sky130_fd_pr__nfet_01v8  w=0.5  l=0.5
X_rhebb_10_7  iwrite_route_10_7  inp_upper_7  ierr_dig_10  vcm_route  vdd vss  hebbian_mult
XMPRED_r_10_8  i_pred_10  vw_route_10_8  vss  vss  sky130_fd_pr__nfet_01v8  w=4  l=0.35
Cw_route_10_8  vw_route_10_8  vss  200f
R_bleed_10_8  vw_route_10_8  vss  10000meg
XMN4_r_10_8  vw_route_10_8  we_route  iwrite_route_10_8  vss  sky130_fd_pr__nfet_01v8  w=0.5  l=0.5
X_rhebb_10_8  iwrite_route_10_8  inp_upper_8  ierr_dig_10  vcm_route  vdd vss  hebbian_mult
XMPRED_r_10_9  i_pred_10  vw_route_10_9  vss  vss  sky130_fd_pr__nfet_01v8  w=4  l=0.35
Cw_route_10_9  vw_route_10_9  vss  200f
R_bleed_10_9  vw_route_10_9  vss  10000meg
XMN4_r_10_9  vw_route_10_9  we_route  iwrite_route_10_9  vss  sky130_fd_pr__nfet_01v8  w=0.5  l=0.5
X_rhebb_10_9  iwrite_route_10_9  inp_upper_9  ierr_dig_10  vcm_route  vdd vss  hebbian_mult
XMPRED_r_10_10  i_pred_10  vw_route_10_10  vss  vss  sky130_fd_pr__nfet_01v8  w=4  l=0.35
Cw_route_10_10  vw_route_10_10  vss  200f
R_bleed_10_10  vw_route_10_10  vss  10000meg
XMN4_r_10_10  vw_route_10_10  we_route  iwrite_route_10_10  vss  sky130_fd_pr__nfet_01v8  w=0.5  l=0.5
X_rhebb_10_10  iwrite_route_10_10  inp_upper_10  ierr_dig_10  vcm_route  vdd vss  hebbian_mult
XMPRED_r_10_11  i_pred_10  vw_route_10_11  vss  vss  sky130_fd_pr__nfet_01v8  w=4  l=0.35
Cw_route_10_11  vw_route_10_11  vss  200f
R_bleed_10_11  vw_route_10_11  vss  10000meg
XMN4_r_10_11  vw_route_10_11  we_route  iwrite_route_10_11  vss  sky130_fd_pr__nfet_01v8  w=0.5  l=0.5
X_rhebb_10_11  iwrite_route_10_11  inp_upper_11  ierr_dig_10  vcm_route  vdd vss  hebbian_mult
XMPRED_r_10_12  i_pred_10  vw_route_10_12  vss  vss  sky130_fd_pr__nfet_01v8  w=4  l=0.35
Cw_route_10_12  vw_route_10_12  vss  200f
R_bleed_10_12  vw_route_10_12  vss  10000meg
XMN4_r_10_12  vw_route_10_12  we_route  iwrite_route_10_12  vss  sky130_fd_pr__nfet_01v8  w=0.5  l=0.5
X_rhebb_10_12  iwrite_route_10_12  inp_upper_12  ierr_dig_10  vcm_route  vdd vss  hebbian_mult
XMPRED_r_10_13  i_pred_10  vw_route_10_13  vss  vss  sky130_fd_pr__nfet_01v8  w=4  l=0.35
Cw_route_10_13  vw_route_10_13  vss  200f
R_bleed_10_13  vw_route_10_13  vss  10000meg
XMN4_r_10_13  vw_route_10_13  we_route  iwrite_route_10_13  vss  sky130_fd_pr__nfet_01v8  w=0.5  l=0.5
X_rhebb_10_13  iwrite_route_10_13  inp_upper_13  ierr_dig_10  vcm_route  vdd vss  hebbian_mult
XMPRED_r_10_14  i_pred_10  vw_route_10_14  vss  vss  sky130_fd_pr__nfet_01v8  w=4  l=0.35
Cw_route_10_14  vw_route_10_14  vss  200f
R_bleed_10_14  vw_route_10_14  vss  10000meg
XMN4_r_10_14  vw_route_10_14  we_route  iwrite_route_10_14  vss  sky130_fd_pr__nfet_01v8  w=0.5  l=0.5
X_rhebb_10_14  iwrite_route_10_14  inp_upper_14  ierr_dig_10  vcm_route  vdd vss  hebbian_mult
XMPRED_r_10_15  i_pred_10  vw_route_10_15  vss  vss  sky130_fd_pr__nfet_01v8  w=4  l=0.35
Cw_route_10_15  vw_route_10_15  vss  200f
R_bleed_10_15  vw_route_10_15  vss  10000meg
XMN4_r_10_15  vw_route_10_15  we_route  iwrite_route_10_15  vss  sky130_fd_pr__nfet_01v8  w=0.5  l=0.5
X_rhebb_10_15  iwrite_route_10_15  inp_upper_15  ierr_dig_10  vcm_route  vdd vss  hebbian_mult

* ── Destination row 11 ── 16 source connections ──────────────────────────
XMPRED_r_11_0  i_pred_11  vw_route_11_0  vss  vss  sky130_fd_pr__nfet_01v8  w=4  l=0.35
Cw_route_11_0  vw_route_11_0  vss  200f
R_bleed_11_0  vw_route_11_0  vss  10000meg
XMN4_r_11_0  vw_route_11_0  we_route  iwrite_route_11_0  vss  sky130_fd_pr__nfet_01v8  w=0.5  l=0.5
X_rhebb_11_0  iwrite_route_11_0  inp_upper_0  ierr_dig_11  vcm_route  vdd vss  hebbian_mult
XMPRED_r_11_1  i_pred_11  vw_route_11_1  vss  vss  sky130_fd_pr__nfet_01v8  w=4  l=0.35
Cw_route_11_1  vw_route_11_1  vss  200f
R_bleed_11_1  vw_route_11_1  vss  10000meg
XMN4_r_11_1  vw_route_11_1  we_route  iwrite_route_11_1  vss  sky130_fd_pr__nfet_01v8  w=0.5  l=0.5
X_rhebb_11_1  iwrite_route_11_1  inp_upper_1  ierr_dig_11  vcm_route  vdd vss  hebbian_mult
XMPRED_r_11_2  i_pred_11  vw_route_11_2  vss  vss  sky130_fd_pr__nfet_01v8  w=4  l=0.35
Cw_route_11_2  vw_route_11_2  vss  200f
R_bleed_11_2  vw_route_11_2  vss  10000meg
XMN4_r_11_2  vw_route_11_2  we_route  iwrite_route_11_2  vss  sky130_fd_pr__nfet_01v8  w=0.5  l=0.5
X_rhebb_11_2  iwrite_route_11_2  inp_upper_2  ierr_dig_11  vcm_route  vdd vss  hebbian_mult
XMPRED_r_11_3  i_pred_11  vw_route_11_3  vss  vss  sky130_fd_pr__nfet_01v8  w=4  l=0.35
Cw_route_11_3  vw_route_11_3  vss  200f
R_bleed_11_3  vw_route_11_3  vss  10000meg
XMN4_r_11_3  vw_route_11_3  we_route  iwrite_route_11_3  vss  sky130_fd_pr__nfet_01v8  w=0.5  l=0.5
X_rhebb_11_3  iwrite_route_11_3  inp_upper_3  ierr_dig_11  vcm_route  vdd vss  hebbian_mult
XMPRED_r_11_4  i_pred_11  vw_route_11_4  vss  vss  sky130_fd_pr__nfet_01v8  w=4  l=0.35
Cw_route_11_4  vw_route_11_4  vss  200f
R_bleed_11_4  vw_route_11_4  vss  10000meg
XMN4_r_11_4  vw_route_11_4  we_route  iwrite_route_11_4  vss  sky130_fd_pr__nfet_01v8  w=0.5  l=0.5
X_rhebb_11_4  iwrite_route_11_4  inp_upper_4  ierr_dig_11  vcm_route  vdd vss  hebbian_mult
XMPRED_r_11_5  i_pred_11  vw_route_11_5  vss  vss  sky130_fd_pr__nfet_01v8  w=4  l=0.35
Cw_route_11_5  vw_route_11_5  vss  200f
R_bleed_11_5  vw_route_11_5  vss  10000meg
XMN4_r_11_5  vw_route_11_5  we_route  iwrite_route_11_5  vss  sky130_fd_pr__nfet_01v8  w=0.5  l=0.5
X_rhebb_11_5  iwrite_route_11_5  inp_upper_5  ierr_dig_11  vcm_route  vdd vss  hebbian_mult
XMPRED_r_11_6  i_pred_11  vw_route_11_6  vss  vss  sky130_fd_pr__nfet_01v8  w=4  l=0.35
Cw_route_11_6  vw_route_11_6  vss  200f
R_bleed_11_6  vw_route_11_6  vss  10000meg
XMN4_r_11_6  vw_route_11_6  we_route  iwrite_route_11_6  vss  sky130_fd_pr__nfet_01v8  w=0.5  l=0.5
X_rhebb_11_6  iwrite_route_11_6  inp_upper_6  ierr_dig_11  vcm_route  vdd vss  hebbian_mult
XMPRED_r_11_7  i_pred_11  vw_route_11_7  vss  vss  sky130_fd_pr__nfet_01v8  w=4  l=0.35
Cw_route_11_7  vw_route_11_7  vss  200f
R_bleed_11_7  vw_route_11_7  vss  10000meg
XMN4_r_11_7  vw_route_11_7  we_route  iwrite_route_11_7  vss  sky130_fd_pr__nfet_01v8  w=0.5  l=0.5
X_rhebb_11_7  iwrite_route_11_7  inp_upper_7  ierr_dig_11  vcm_route  vdd vss  hebbian_mult
XMPRED_r_11_8  i_pred_11  vw_route_11_8  vss  vss  sky130_fd_pr__nfet_01v8  w=4  l=0.35
Cw_route_11_8  vw_route_11_8  vss  200f
R_bleed_11_8  vw_route_11_8  vss  10000meg
XMN4_r_11_8  vw_route_11_8  we_route  iwrite_route_11_8  vss  sky130_fd_pr__nfet_01v8  w=0.5  l=0.5
X_rhebb_11_8  iwrite_route_11_8  inp_upper_8  ierr_dig_11  vcm_route  vdd vss  hebbian_mult
XMPRED_r_11_9  i_pred_11  vw_route_11_9  vss  vss  sky130_fd_pr__nfet_01v8  w=4  l=0.35
Cw_route_11_9  vw_route_11_9  vss  200f
R_bleed_11_9  vw_route_11_9  vss  10000meg
XMN4_r_11_9  vw_route_11_9  we_route  iwrite_route_11_9  vss  sky130_fd_pr__nfet_01v8  w=0.5  l=0.5
X_rhebb_11_9  iwrite_route_11_9  inp_upper_9  ierr_dig_11  vcm_route  vdd vss  hebbian_mult
XMPRED_r_11_10  i_pred_11  vw_route_11_10  vss  vss  sky130_fd_pr__nfet_01v8  w=4  l=0.35
Cw_route_11_10  vw_route_11_10  vss  200f
R_bleed_11_10  vw_route_11_10  vss  10000meg
XMN4_r_11_10  vw_route_11_10  we_route  iwrite_route_11_10  vss  sky130_fd_pr__nfet_01v8  w=0.5  l=0.5
X_rhebb_11_10  iwrite_route_11_10  inp_upper_10  ierr_dig_11  vcm_route  vdd vss  hebbian_mult
XMPRED_r_11_11  i_pred_11  vw_route_11_11  vss  vss  sky130_fd_pr__nfet_01v8  w=4  l=0.35
Cw_route_11_11  vw_route_11_11  vss  200f
R_bleed_11_11  vw_route_11_11  vss  10000meg
XMN4_r_11_11  vw_route_11_11  we_route  iwrite_route_11_11  vss  sky130_fd_pr__nfet_01v8  w=0.5  l=0.5
X_rhebb_11_11  iwrite_route_11_11  inp_upper_11  ierr_dig_11  vcm_route  vdd vss  hebbian_mult
XMPRED_r_11_12  i_pred_11  vw_route_11_12  vss  vss  sky130_fd_pr__nfet_01v8  w=4  l=0.35
Cw_route_11_12  vw_route_11_12  vss  200f
R_bleed_11_12  vw_route_11_12  vss  10000meg
XMN4_r_11_12  vw_route_11_12  we_route  iwrite_route_11_12  vss  sky130_fd_pr__nfet_01v8  w=0.5  l=0.5
X_rhebb_11_12  iwrite_route_11_12  inp_upper_12  ierr_dig_11  vcm_route  vdd vss  hebbian_mult
XMPRED_r_11_13  i_pred_11  vw_route_11_13  vss  vss  sky130_fd_pr__nfet_01v8  w=4  l=0.35
Cw_route_11_13  vw_route_11_13  vss  200f
R_bleed_11_13  vw_route_11_13  vss  10000meg
XMN4_r_11_13  vw_route_11_13  we_route  iwrite_route_11_13  vss  sky130_fd_pr__nfet_01v8  w=0.5  l=0.5
X_rhebb_11_13  iwrite_route_11_13  inp_upper_13  ierr_dig_11  vcm_route  vdd vss  hebbian_mult
XMPRED_r_11_14  i_pred_11  vw_route_11_14  vss  vss  sky130_fd_pr__nfet_01v8  w=4  l=0.35
Cw_route_11_14  vw_route_11_14  vss  200f
R_bleed_11_14  vw_route_11_14  vss  10000meg
XMN4_r_11_14  vw_route_11_14  we_route  iwrite_route_11_14  vss  sky130_fd_pr__nfet_01v8  w=0.5  l=0.5
X_rhebb_11_14  iwrite_route_11_14  inp_upper_14  ierr_dig_11  vcm_route  vdd vss  hebbian_mult
XMPRED_r_11_15  i_pred_11  vw_route_11_15  vss  vss  sky130_fd_pr__nfet_01v8  w=4  l=0.35
Cw_route_11_15  vw_route_11_15  vss  200f
R_bleed_11_15  vw_route_11_15  vss  10000meg
XMN4_r_11_15  vw_route_11_15  we_route  iwrite_route_11_15  vss  sky130_fd_pr__nfet_01v8  w=0.5  l=0.5
X_rhebb_11_15  iwrite_route_11_15  inp_upper_15  ierr_dig_11  vcm_route  vdd vss  hebbian_mult

* ── Destination row 12 ── 16 source connections ──────────────────────────
XMPRED_r_12_0  i_pred_12  vw_route_12_0  vss  vss  sky130_fd_pr__nfet_01v8  w=4  l=0.35
Cw_route_12_0  vw_route_12_0  vss  200f
R_bleed_12_0  vw_route_12_0  vss  10000meg
XMN4_r_12_0  vw_route_12_0  we_route  iwrite_route_12_0  vss  sky130_fd_pr__nfet_01v8  w=0.5  l=0.5
X_rhebb_12_0  iwrite_route_12_0  inp_upper_0  ierr_dig_12  vcm_route  vdd vss  hebbian_mult
XMPRED_r_12_1  i_pred_12  vw_route_12_1  vss  vss  sky130_fd_pr__nfet_01v8  w=4  l=0.35
Cw_route_12_1  vw_route_12_1  vss  200f
R_bleed_12_1  vw_route_12_1  vss  10000meg
XMN4_r_12_1  vw_route_12_1  we_route  iwrite_route_12_1  vss  sky130_fd_pr__nfet_01v8  w=0.5  l=0.5
X_rhebb_12_1  iwrite_route_12_1  inp_upper_1  ierr_dig_12  vcm_route  vdd vss  hebbian_mult
XMPRED_r_12_2  i_pred_12  vw_route_12_2  vss  vss  sky130_fd_pr__nfet_01v8  w=4  l=0.35
Cw_route_12_2  vw_route_12_2  vss  200f
R_bleed_12_2  vw_route_12_2  vss  10000meg
XMN4_r_12_2  vw_route_12_2  we_route  iwrite_route_12_2  vss  sky130_fd_pr__nfet_01v8  w=0.5  l=0.5
X_rhebb_12_2  iwrite_route_12_2  inp_upper_2  ierr_dig_12  vcm_route  vdd vss  hebbian_mult
XMPRED_r_12_3  i_pred_12  vw_route_12_3  vss  vss  sky130_fd_pr__nfet_01v8  w=4  l=0.35
Cw_route_12_3  vw_route_12_3  vss  200f
R_bleed_12_3  vw_route_12_3  vss  10000meg
XMN4_r_12_3  vw_route_12_3  we_route  iwrite_route_12_3  vss  sky130_fd_pr__nfet_01v8  w=0.5  l=0.5
X_rhebb_12_3  iwrite_route_12_3  inp_upper_3  ierr_dig_12  vcm_route  vdd vss  hebbian_mult
XMPRED_r_12_4  i_pred_12  vw_route_12_4  vss  vss  sky130_fd_pr__nfet_01v8  w=4  l=0.35
Cw_route_12_4  vw_route_12_4  vss  200f
R_bleed_12_4  vw_route_12_4  vss  10000meg
XMN4_r_12_4  vw_route_12_4  we_route  iwrite_route_12_4  vss  sky130_fd_pr__nfet_01v8  w=0.5  l=0.5
X_rhebb_12_4  iwrite_route_12_4  inp_upper_4  ierr_dig_12  vcm_route  vdd vss  hebbian_mult
XMPRED_r_12_5  i_pred_12  vw_route_12_5  vss  vss  sky130_fd_pr__nfet_01v8  w=4  l=0.35
Cw_route_12_5  vw_route_12_5  vss  200f
R_bleed_12_5  vw_route_12_5  vss  10000meg
XMN4_r_12_5  vw_route_12_5  we_route  iwrite_route_12_5  vss  sky130_fd_pr__nfet_01v8  w=0.5  l=0.5
X_rhebb_12_5  iwrite_route_12_5  inp_upper_5  ierr_dig_12  vcm_route  vdd vss  hebbian_mult
XMPRED_r_12_6  i_pred_12  vw_route_12_6  vss  vss  sky130_fd_pr__nfet_01v8  w=4  l=0.35
Cw_route_12_6  vw_route_12_6  vss  200f
R_bleed_12_6  vw_route_12_6  vss  10000meg
XMN4_r_12_6  vw_route_12_6  we_route  iwrite_route_12_6  vss  sky130_fd_pr__nfet_01v8  w=0.5  l=0.5
X_rhebb_12_6  iwrite_route_12_6  inp_upper_6  ierr_dig_12  vcm_route  vdd vss  hebbian_mult
XMPRED_r_12_7  i_pred_12  vw_route_12_7  vss  vss  sky130_fd_pr__nfet_01v8  w=4  l=0.35
Cw_route_12_7  vw_route_12_7  vss  200f
R_bleed_12_7  vw_route_12_7  vss  10000meg
XMN4_r_12_7  vw_route_12_7  we_route  iwrite_route_12_7  vss  sky130_fd_pr__nfet_01v8  w=0.5  l=0.5
X_rhebb_12_7  iwrite_route_12_7  inp_upper_7  ierr_dig_12  vcm_route  vdd vss  hebbian_mult
XMPRED_r_12_8  i_pred_12  vw_route_12_8  vss  vss  sky130_fd_pr__nfet_01v8  w=4  l=0.35
Cw_route_12_8  vw_route_12_8  vss  200f
R_bleed_12_8  vw_route_12_8  vss  10000meg
XMN4_r_12_8  vw_route_12_8  we_route  iwrite_route_12_8  vss  sky130_fd_pr__nfet_01v8  w=0.5  l=0.5
X_rhebb_12_8  iwrite_route_12_8  inp_upper_8  ierr_dig_12  vcm_route  vdd vss  hebbian_mult
XMPRED_r_12_9  i_pred_12  vw_route_12_9  vss  vss  sky130_fd_pr__nfet_01v8  w=4  l=0.35
Cw_route_12_9  vw_route_12_9  vss  200f
R_bleed_12_9  vw_route_12_9  vss  10000meg
XMN4_r_12_9  vw_route_12_9  we_route  iwrite_route_12_9  vss  sky130_fd_pr__nfet_01v8  w=0.5  l=0.5
X_rhebb_12_9  iwrite_route_12_9  inp_upper_9  ierr_dig_12  vcm_route  vdd vss  hebbian_mult
XMPRED_r_12_10  i_pred_12  vw_route_12_10  vss  vss  sky130_fd_pr__nfet_01v8  w=4  l=0.35
Cw_route_12_10  vw_route_12_10  vss  200f
R_bleed_12_10  vw_route_12_10  vss  10000meg
XMN4_r_12_10  vw_route_12_10  we_route  iwrite_route_12_10  vss  sky130_fd_pr__nfet_01v8  w=0.5  l=0.5
X_rhebb_12_10  iwrite_route_12_10  inp_upper_10  ierr_dig_12  vcm_route  vdd vss  hebbian_mult
XMPRED_r_12_11  i_pred_12  vw_route_12_11  vss  vss  sky130_fd_pr__nfet_01v8  w=4  l=0.35
Cw_route_12_11  vw_route_12_11  vss  200f
R_bleed_12_11  vw_route_12_11  vss  10000meg
XMN4_r_12_11  vw_route_12_11  we_route  iwrite_route_12_11  vss  sky130_fd_pr__nfet_01v8  w=0.5  l=0.5
X_rhebb_12_11  iwrite_route_12_11  inp_upper_11  ierr_dig_12  vcm_route  vdd vss  hebbian_mult
XMPRED_r_12_12  i_pred_12  vw_route_12_12  vss  vss  sky130_fd_pr__nfet_01v8  w=4  l=0.35
Cw_route_12_12  vw_route_12_12  vss  200f
R_bleed_12_12  vw_route_12_12  vss  10000meg
XMN4_r_12_12  vw_route_12_12  we_route  iwrite_route_12_12  vss  sky130_fd_pr__nfet_01v8  w=0.5  l=0.5
X_rhebb_12_12  iwrite_route_12_12  inp_upper_12  ierr_dig_12  vcm_route  vdd vss  hebbian_mult
XMPRED_r_12_13  i_pred_12  vw_route_12_13  vss  vss  sky130_fd_pr__nfet_01v8  w=4  l=0.35
Cw_route_12_13  vw_route_12_13  vss  200f
R_bleed_12_13  vw_route_12_13  vss  10000meg
XMN4_r_12_13  vw_route_12_13  we_route  iwrite_route_12_13  vss  sky130_fd_pr__nfet_01v8  w=0.5  l=0.5
X_rhebb_12_13  iwrite_route_12_13  inp_upper_13  ierr_dig_12  vcm_route  vdd vss  hebbian_mult
XMPRED_r_12_14  i_pred_12  vw_route_12_14  vss  vss  sky130_fd_pr__nfet_01v8  w=4  l=0.35
Cw_route_12_14  vw_route_12_14  vss  200f
R_bleed_12_14  vw_route_12_14  vss  10000meg
XMN4_r_12_14  vw_route_12_14  we_route  iwrite_route_12_14  vss  sky130_fd_pr__nfet_01v8  w=0.5  l=0.5
X_rhebb_12_14  iwrite_route_12_14  inp_upper_14  ierr_dig_12  vcm_route  vdd vss  hebbian_mult
XMPRED_r_12_15  i_pred_12  vw_route_12_15  vss  vss  sky130_fd_pr__nfet_01v8  w=4  l=0.35
Cw_route_12_15  vw_route_12_15  vss  200f
R_bleed_12_15  vw_route_12_15  vss  10000meg
XMN4_r_12_15  vw_route_12_15  we_route  iwrite_route_12_15  vss  sky130_fd_pr__nfet_01v8  w=0.5  l=0.5
X_rhebb_12_15  iwrite_route_12_15  inp_upper_15  ierr_dig_12  vcm_route  vdd vss  hebbian_mult

* ── Destination row 13 ── 16 source connections ──────────────────────────
XMPRED_r_13_0  i_pred_13  vw_route_13_0  vss  vss  sky130_fd_pr__nfet_01v8  w=4  l=0.35
Cw_route_13_0  vw_route_13_0  vss  200f
R_bleed_13_0  vw_route_13_0  vss  10000meg
XMN4_r_13_0  vw_route_13_0  we_route  iwrite_route_13_0  vss  sky130_fd_pr__nfet_01v8  w=0.5  l=0.5
X_rhebb_13_0  iwrite_route_13_0  inp_upper_0  ierr_dig_13  vcm_route  vdd vss  hebbian_mult
XMPRED_r_13_1  i_pred_13  vw_route_13_1  vss  vss  sky130_fd_pr__nfet_01v8  w=4  l=0.35
Cw_route_13_1  vw_route_13_1  vss  200f
R_bleed_13_1  vw_route_13_1  vss  10000meg
XMN4_r_13_1  vw_route_13_1  we_route  iwrite_route_13_1  vss  sky130_fd_pr__nfet_01v8  w=0.5  l=0.5
X_rhebb_13_1  iwrite_route_13_1  inp_upper_1  ierr_dig_13  vcm_route  vdd vss  hebbian_mult
XMPRED_r_13_2  i_pred_13  vw_route_13_2  vss  vss  sky130_fd_pr__nfet_01v8  w=4  l=0.35
Cw_route_13_2  vw_route_13_2  vss  200f
R_bleed_13_2  vw_route_13_2  vss  10000meg
XMN4_r_13_2  vw_route_13_2  we_route  iwrite_route_13_2  vss  sky130_fd_pr__nfet_01v8  w=0.5  l=0.5
X_rhebb_13_2  iwrite_route_13_2  inp_upper_2  ierr_dig_13  vcm_route  vdd vss  hebbian_mult
XMPRED_r_13_3  i_pred_13  vw_route_13_3  vss  vss  sky130_fd_pr__nfet_01v8  w=4  l=0.35
Cw_route_13_3  vw_route_13_3  vss  200f
R_bleed_13_3  vw_route_13_3  vss  10000meg
XMN4_r_13_3  vw_route_13_3  we_route  iwrite_route_13_3  vss  sky130_fd_pr__nfet_01v8  w=0.5  l=0.5
X_rhebb_13_3  iwrite_route_13_3  inp_upper_3  ierr_dig_13  vcm_route  vdd vss  hebbian_mult
XMPRED_r_13_4  i_pred_13  vw_route_13_4  vss  vss  sky130_fd_pr__nfet_01v8  w=4  l=0.35
Cw_route_13_4  vw_route_13_4  vss  200f
R_bleed_13_4  vw_route_13_4  vss  10000meg
XMN4_r_13_4  vw_route_13_4  we_route  iwrite_route_13_4  vss  sky130_fd_pr__nfet_01v8  w=0.5  l=0.5
X_rhebb_13_4  iwrite_route_13_4  inp_upper_4  ierr_dig_13  vcm_route  vdd vss  hebbian_mult
XMPRED_r_13_5  i_pred_13  vw_route_13_5  vss  vss  sky130_fd_pr__nfet_01v8  w=4  l=0.35
Cw_route_13_5  vw_route_13_5  vss  200f
R_bleed_13_5  vw_route_13_5  vss  10000meg
XMN4_r_13_5  vw_route_13_5  we_route  iwrite_route_13_5  vss  sky130_fd_pr__nfet_01v8  w=0.5  l=0.5
X_rhebb_13_5  iwrite_route_13_5  inp_upper_5  ierr_dig_13  vcm_route  vdd vss  hebbian_mult
XMPRED_r_13_6  i_pred_13  vw_route_13_6  vss  vss  sky130_fd_pr__nfet_01v8  w=4  l=0.35
Cw_route_13_6  vw_route_13_6  vss  200f
R_bleed_13_6  vw_route_13_6  vss  10000meg
XMN4_r_13_6  vw_route_13_6  we_route  iwrite_route_13_6  vss  sky130_fd_pr__nfet_01v8  w=0.5  l=0.5
X_rhebb_13_6  iwrite_route_13_6  inp_upper_6  ierr_dig_13  vcm_route  vdd vss  hebbian_mult
XMPRED_r_13_7  i_pred_13  vw_route_13_7  vss  vss  sky130_fd_pr__nfet_01v8  w=4  l=0.35
Cw_route_13_7  vw_route_13_7  vss  200f
R_bleed_13_7  vw_route_13_7  vss  10000meg
XMN4_r_13_7  vw_route_13_7  we_route  iwrite_route_13_7  vss  sky130_fd_pr__nfet_01v8  w=0.5  l=0.5
X_rhebb_13_7  iwrite_route_13_7  inp_upper_7  ierr_dig_13  vcm_route  vdd vss  hebbian_mult
XMPRED_r_13_8  i_pred_13  vw_route_13_8  vss  vss  sky130_fd_pr__nfet_01v8  w=4  l=0.35
Cw_route_13_8  vw_route_13_8  vss  200f
R_bleed_13_8  vw_route_13_8  vss  10000meg
XMN4_r_13_8  vw_route_13_8  we_route  iwrite_route_13_8  vss  sky130_fd_pr__nfet_01v8  w=0.5  l=0.5
X_rhebb_13_8  iwrite_route_13_8  inp_upper_8  ierr_dig_13  vcm_route  vdd vss  hebbian_mult
XMPRED_r_13_9  i_pred_13  vw_route_13_9  vss  vss  sky130_fd_pr__nfet_01v8  w=4  l=0.35
Cw_route_13_9  vw_route_13_9  vss  200f
R_bleed_13_9  vw_route_13_9  vss  10000meg
XMN4_r_13_9  vw_route_13_9  we_route  iwrite_route_13_9  vss  sky130_fd_pr__nfet_01v8  w=0.5  l=0.5
X_rhebb_13_9  iwrite_route_13_9  inp_upper_9  ierr_dig_13  vcm_route  vdd vss  hebbian_mult
XMPRED_r_13_10  i_pred_13  vw_route_13_10  vss  vss  sky130_fd_pr__nfet_01v8  w=4  l=0.35
Cw_route_13_10  vw_route_13_10  vss  200f
R_bleed_13_10  vw_route_13_10  vss  10000meg
XMN4_r_13_10  vw_route_13_10  we_route  iwrite_route_13_10  vss  sky130_fd_pr__nfet_01v8  w=0.5  l=0.5
X_rhebb_13_10  iwrite_route_13_10  inp_upper_10  ierr_dig_13  vcm_route  vdd vss  hebbian_mult
XMPRED_r_13_11  i_pred_13  vw_route_13_11  vss  vss  sky130_fd_pr__nfet_01v8  w=4  l=0.35
Cw_route_13_11  vw_route_13_11  vss  200f
R_bleed_13_11  vw_route_13_11  vss  10000meg
XMN4_r_13_11  vw_route_13_11  we_route  iwrite_route_13_11  vss  sky130_fd_pr__nfet_01v8  w=0.5  l=0.5
X_rhebb_13_11  iwrite_route_13_11  inp_upper_11  ierr_dig_13  vcm_route  vdd vss  hebbian_mult
XMPRED_r_13_12  i_pred_13  vw_route_13_12  vss  vss  sky130_fd_pr__nfet_01v8  w=4  l=0.35
Cw_route_13_12  vw_route_13_12  vss  200f
R_bleed_13_12  vw_route_13_12  vss  10000meg
XMN4_r_13_12  vw_route_13_12  we_route  iwrite_route_13_12  vss  sky130_fd_pr__nfet_01v8  w=0.5  l=0.5
X_rhebb_13_12  iwrite_route_13_12  inp_upper_12  ierr_dig_13  vcm_route  vdd vss  hebbian_mult
XMPRED_r_13_13  i_pred_13  vw_route_13_13  vss  vss  sky130_fd_pr__nfet_01v8  w=4  l=0.35
Cw_route_13_13  vw_route_13_13  vss  200f
R_bleed_13_13  vw_route_13_13  vss  10000meg
XMN4_r_13_13  vw_route_13_13  we_route  iwrite_route_13_13  vss  sky130_fd_pr__nfet_01v8  w=0.5  l=0.5
X_rhebb_13_13  iwrite_route_13_13  inp_upper_13  ierr_dig_13  vcm_route  vdd vss  hebbian_mult
XMPRED_r_13_14  i_pred_13  vw_route_13_14  vss  vss  sky130_fd_pr__nfet_01v8  w=4  l=0.35
Cw_route_13_14  vw_route_13_14  vss  200f
R_bleed_13_14  vw_route_13_14  vss  10000meg
XMN4_r_13_14  vw_route_13_14  we_route  iwrite_route_13_14  vss  sky130_fd_pr__nfet_01v8  w=0.5  l=0.5
X_rhebb_13_14  iwrite_route_13_14  inp_upper_14  ierr_dig_13  vcm_route  vdd vss  hebbian_mult
XMPRED_r_13_15  i_pred_13  vw_route_13_15  vss  vss  sky130_fd_pr__nfet_01v8  w=4  l=0.35
Cw_route_13_15  vw_route_13_15  vss  200f
R_bleed_13_15  vw_route_13_15  vss  10000meg
XMN4_r_13_15  vw_route_13_15  we_route  iwrite_route_13_15  vss  sky130_fd_pr__nfet_01v8  w=0.5  l=0.5
X_rhebb_13_15  iwrite_route_13_15  inp_upper_15  ierr_dig_13  vcm_route  vdd vss  hebbian_mult

* ── Destination row 14 ── 16 source connections ──────────────────────────
XMPRED_r_14_0  i_pred_14  vw_route_14_0  vss  vss  sky130_fd_pr__nfet_01v8  w=4  l=0.35
Cw_route_14_0  vw_route_14_0  vss  200f
R_bleed_14_0  vw_route_14_0  vss  10000meg
XMN4_r_14_0  vw_route_14_0  we_route  iwrite_route_14_0  vss  sky130_fd_pr__nfet_01v8  w=0.5  l=0.5
X_rhebb_14_0  iwrite_route_14_0  inp_upper_0  ierr_dig_14  vcm_route  vdd vss  hebbian_mult
XMPRED_r_14_1  i_pred_14  vw_route_14_1  vss  vss  sky130_fd_pr__nfet_01v8  w=4  l=0.35
Cw_route_14_1  vw_route_14_1  vss  200f
R_bleed_14_1  vw_route_14_1  vss  10000meg
XMN4_r_14_1  vw_route_14_1  we_route  iwrite_route_14_1  vss  sky130_fd_pr__nfet_01v8  w=0.5  l=0.5
X_rhebb_14_1  iwrite_route_14_1  inp_upper_1  ierr_dig_14  vcm_route  vdd vss  hebbian_mult
XMPRED_r_14_2  i_pred_14  vw_route_14_2  vss  vss  sky130_fd_pr__nfet_01v8  w=4  l=0.35
Cw_route_14_2  vw_route_14_2  vss  200f
R_bleed_14_2  vw_route_14_2  vss  10000meg
XMN4_r_14_2  vw_route_14_2  we_route  iwrite_route_14_2  vss  sky130_fd_pr__nfet_01v8  w=0.5  l=0.5
X_rhebb_14_2  iwrite_route_14_2  inp_upper_2  ierr_dig_14  vcm_route  vdd vss  hebbian_mult
XMPRED_r_14_3  i_pred_14  vw_route_14_3  vss  vss  sky130_fd_pr__nfet_01v8  w=4  l=0.35
Cw_route_14_3  vw_route_14_3  vss  200f
R_bleed_14_3  vw_route_14_3  vss  10000meg
XMN4_r_14_3  vw_route_14_3  we_route  iwrite_route_14_3  vss  sky130_fd_pr__nfet_01v8  w=0.5  l=0.5
X_rhebb_14_3  iwrite_route_14_3  inp_upper_3  ierr_dig_14  vcm_route  vdd vss  hebbian_mult
XMPRED_r_14_4  i_pred_14  vw_route_14_4  vss  vss  sky130_fd_pr__nfet_01v8  w=4  l=0.35
Cw_route_14_4  vw_route_14_4  vss  200f
R_bleed_14_4  vw_route_14_4  vss  10000meg
XMN4_r_14_4  vw_route_14_4  we_route  iwrite_route_14_4  vss  sky130_fd_pr__nfet_01v8  w=0.5  l=0.5
X_rhebb_14_4  iwrite_route_14_4  inp_upper_4  ierr_dig_14  vcm_route  vdd vss  hebbian_mult
XMPRED_r_14_5  i_pred_14  vw_route_14_5  vss  vss  sky130_fd_pr__nfet_01v8  w=4  l=0.35
Cw_route_14_5  vw_route_14_5  vss  200f
R_bleed_14_5  vw_route_14_5  vss  10000meg
XMN4_r_14_5  vw_route_14_5  we_route  iwrite_route_14_5  vss  sky130_fd_pr__nfet_01v8  w=0.5  l=0.5
X_rhebb_14_5  iwrite_route_14_5  inp_upper_5  ierr_dig_14  vcm_route  vdd vss  hebbian_mult
XMPRED_r_14_6  i_pred_14  vw_route_14_6  vss  vss  sky130_fd_pr__nfet_01v8  w=4  l=0.35
Cw_route_14_6  vw_route_14_6  vss  200f
R_bleed_14_6  vw_route_14_6  vss  10000meg
XMN4_r_14_6  vw_route_14_6  we_route  iwrite_route_14_6  vss  sky130_fd_pr__nfet_01v8  w=0.5  l=0.5
X_rhebb_14_6  iwrite_route_14_6  inp_upper_6  ierr_dig_14  vcm_route  vdd vss  hebbian_mult
XMPRED_r_14_7  i_pred_14  vw_route_14_7  vss  vss  sky130_fd_pr__nfet_01v8  w=4  l=0.35
Cw_route_14_7  vw_route_14_7  vss  200f
R_bleed_14_7  vw_route_14_7  vss  10000meg
XMN4_r_14_7  vw_route_14_7  we_route  iwrite_route_14_7  vss  sky130_fd_pr__nfet_01v8  w=0.5  l=0.5
X_rhebb_14_7  iwrite_route_14_7  inp_upper_7  ierr_dig_14  vcm_route  vdd vss  hebbian_mult
XMPRED_r_14_8  i_pred_14  vw_route_14_8  vss  vss  sky130_fd_pr__nfet_01v8  w=4  l=0.35
Cw_route_14_8  vw_route_14_8  vss  200f
R_bleed_14_8  vw_route_14_8  vss  10000meg
XMN4_r_14_8  vw_route_14_8  we_route  iwrite_route_14_8  vss  sky130_fd_pr__nfet_01v8  w=0.5  l=0.5
X_rhebb_14_8  iwrite_route_14_8  inp_upper_8  ierr_dig_14  vcm_route  vdd vss  hebbian_mult
XMPRED_r_14_9  i_pred_14  vw_route_14_9  vss  vss  sky130_fd_pr__nfet_01v8  w=4  l=0.35
Cw_route_14_9  vw_route_14_9  vss  200f
R_bleed_14_9  vw_route_14_9  vss  10000meg
XMN4_r_14_9  vw_route_14_9  we_route  iwrite_route_14_9  vss  sky130_fd_pr__nfet_01v8  w=0.5  l=0.5
X_rhebb_14_9  iwrite_route_14_9  inp_upper_9  ierr_dig_14  vcm_route  vdd vss  hebbian_mult
XMPRED_r_14_10  i_pred_14  vw_route_14_10  vss  vss  sky130_fd_pr__nfet_01v8  w=4  l=0.35
Cw_route_14_10  vw_route_14_10  vss  200f
R_bleed_14_10  vw_route_14_10  vss  10000meg
XMN4_r_14_10  vw_route_14_10  we_route  iwrite_route_14_10  vss  sky130_fd_pr__nfet_01v8  w=0.5  l=0.5
X_rhebb_14_10  iwrite_route_14_10  inp_upper_10  ierr_dig_14  vcm_route  vdd vss  hebbian_mult
XMPRED_r_14_11  i_pred_14  vw_route_14_11  vss  vss  sky130_fd_pr__nfet_01v8  w=4  l=0.35
Cw_route_14_11  vw_route_14_11  vss  200f
R_bleed_14_11  vw_route_14_11  vss  10000meg
XMN4_r_14_11  vw_route_14_11  we_route  iwrite_route_14_11  vss  sky130_fd_pr__nfet_01v8  w=0.5  l=0.5
X_rhebb_14_11  iwrite_route_14_11  inp_upper_11  ierr_dig_14  vcm_route  vdd vss  hebbian_mult
XMPRED_r_14_12  i_pred_14  vw_route_14_12  vss  vss  sky130_fd_pr__nfet_01v8  w=4  l=0.35
Cw_route_14_12  vw_route_14_12  vss  200f
R_bleed_14_12  vw_route_14_12  vss  10000meg
XMN4_r_14_12  vw_route_14_12  we_route  iwrite_route_14_12  vss  sky130_fd_pr__nfet_01v8  w=0.5  l=0.5
X_rhebb_14_12  iwrite_route_14_12  inp_upper_12  ierr_dig_14  vcm_route  vdd vss  hebbian_mult
XMPRED_r_14_13  i_pred_14  vw_route_14_13  vss  vss  sky130_fd_pr__nfet_01v8  w=4  l=0.35
Cw_route_14_13  vw_route_14_13  vss  200f
R_bleed_14_13  vw_route_14_13  vss  10000meg
XMN4_r_14_13  vw_route_14_13  we_route  iwrite_route_14_13  vss  sky130_fd_pr__nfet_01v8  w=0.5  l=0.5
X_rhebb_14_13  iwrite_route_14_13  inp_upper_13  ierr_dig_14  vcm_route  vdd vss  hebbian_mult
XMPRED_r_14_14  i_pred_14  vw_route_14_14  vss  vss  sky130_fd_pr__nfet_01v8  w=4  l=0.35
Cw_route_14_14  vw_route_14_14  vss  200f
R_bleed_14_14  vw_route_14_14  vss  10000meg
XMN4_r_14_14  vw_route_14_14  we_route  iwrite_route_14_14  vss  sky130_fd_pr__nfet_01v8  w=0.5  l=0.5
X_rhebb_14_14  iwrite_route_14_14  inp_upper_14  ierr_dig_14  vcm_route  vdd vss  hebbian_mult
XMPRED_r_14_15  i_pred_14  vw_route_14_15  vss  vss  sky130_fd_pr__nfet_01v8  w=4  l=0.35
Cw_route_14_15  vw_route_14_15  vss  200f
R_bleed_14_15  vw_route_14_15  vss  10000meg
XMN4_r_14_15  vw_route_14_15  we_route  iwrite_route_14_15  vss  sky130_fd_pr__nfet_01v8  w=0.5  l=0.5
X_rhebb_14_15  iwrite_route_14_15  inp_upper_15  ierr_dig_14  vcm_route  vdd vss  hebbian_mult

* ── Destination row 15 ── 16 source connections ──────────────────────────
XMPRED_r_15_0  i_pred_15  vw_route_15_0  vss  vss  sky130_fd_pr__nfet_01v8  w=4  l=0.35
Cw_route_15_0  vw_route_15_0  vss  200f
R_bleed_15_0  vw_route_15_0  vss  10000meg
XMN4_r_15_0  vw_route_15_0  we_route  iwrite_route_15_0  vss  sky130_fd_pr__nfet_01v8  w=0.5  l=0.5
X_rhebb_15_0  iwrite_route_15_0  inp_upper_0  ierr_dig_15  vcm_route  vdd vss  hebbian_mult
XMPRED_r_15_1  i_pred_15  vw_route_15_1  vss  vss  sky130_fd_pr__nfet_01v8  w=4  l=0.35
Cw_route_15_1  vw_route_15_1  vss  200f
R_bleed_15_1  vw_route_15_1  vss  10000meg
XMN4_r_15_1  vw_route_15_1  we_route  iwrite_route_15_1  vss  sky130_fd_pr__nfet_01v8  w=0.5  l=0.5
X_rhebb_15_1  iwrite_route_15_1  inp_upper_1  ierr_dig_15  vcm_route  vdd vss  hebbian_mult
XMPRED_r_15_2  i_pred_15  vw_route_15_2  vss  vss  sky130_fd_pr__nfet_01v8  w=4  l=0.35
Cw_route_15_2  vw_route_15_2  vss  200f
R_bleed_15_2  vw_route_15_2  vss  10000meg
XMN4_r_15_2  vw_route_15_2  we_route  iwrite_route_15_2  vss  sky130_fd_pr__nfet_01v8  w=0.5  l=0.5
X_rhebb_15_2  iwrite_route_15_2  inp_upper_2  ierr_dig_15  vcm_route  vdd vss  hebbian_mult
XMPRED_r_15_3  i_pred_15  vw_route_15_3  vss  vss  sky130_fd_pr__nfet_01v8  w=4  l=0.35
Cw_route_15_3  vw_route_15_3  vss  200f
R_bleed_15_3  vw_route_15_3  vss  10000meg
XMN4_r_15_3  vw_route_15_3  we_route  iwrite_route_15_3  vss  sky130_fd_pr__nfet_01v8  w=0.5  l=0.5
X_rhebb_15_3  iwrite_route_15_3  inp_upper_3  ierr_dig_15  vcm_route  vdd vss  hebbian_mult
XMPRED_r_15_4  i_pred_15  vw_route_15_4  vss  vss  sky130_fd_pr__nfet_01v8  w=4  l=0.35
Cw_route_15_4  vw_route_15_4  vss  200f
R_bleed_15_4  vw_route_15_4  vss  10000meg
XMN4_r_15_4  vw_route_15_4  we_route  iwrite_route_15_4  vss  sky130_fd_pr__nfet_01v8  w=0.5  l=0.5
X_rhebb_15_4  iwrite_route_15_4  inp_upper_4  ierr_dig_15  vcm_route  vdd vss  hebbian_mult
XMPRED_r_15_5  i_pred_15  vw_route_15_5  vss  vss  sky130_fd_pr__nfet_01v8  w=4  l=0.35
Cw_route_15_5  vw_route_15_5  vss  200f
R_bleed_15_5  vw_route_15_5  vss  10000meg
XMN4_r_15_5  vw_route_15_5  we_route  iwrite_route_15_5  vss  sky130_fd_pr__nfet_01v8  w=0.5  l=0.5
X_rhebb_15_5  iwrite_route_15_5  inp_upper_5  ierr_dig_15  vcm_route  vdd vss  hebbian_mult
XMPRED_r_15_6  i_pred_15  vw_route_15_6  vss  vss  sky130_fd_pr__nfet_01v8  w=4  l=0.35
Cw_route_15_6  vw_route_15_6  vss  200f
R_bleed_15_6  vw_route_15_6  vss  10000meg
XMN4_r_15_6  vw_route_15_6  we_route  iwrite_route_15_6  vss  sky130_fd_pr__nfet_01v8  w=0.5  l=0.5
X_rhebb_15_6  iwrite_route_15_6  inp_upper_6  ierr_dig_15  vcm_route  vdd vss  hebbian_mult
XMPRED_r_15_7  i_pred_15  vw_route_15_7  vss  vss  sky130_fd_pr__nfet_01v8  w=4  l=0.35
Cw_route_15_7  vw_route_15_7  vss  200f
R_bleed_15_7  vw_route_15_7  vss  10000meg
XMN4_r_15_7  vw_route_15_7  we_route  iwrite_route_15_7  vss  sky130_fd_pr__nfet_01v8  w=0.5  l=0.5
X_rhebb_15_7  iwrite_route_15_7  inp_upper_7  ierr_dig_15  vcm_route  vdd vss  hebbian_mult
XMPRED_r_15_8  i_pred_15  vw_route_15_8  vss  vss  sky130_fd_pr__nfet_01v8  w=4  l=0.35
Cw_route_15_8  vw_route_15_8  vss  200f
R_bleed_15_8  vw_route_15_8  vss  10000meg
XMN4_r_15_8  vw_route_15_8  we_route  iwrite_route_15_8  vss  sky130_fd_pr__nfet_01v8  w=0.5  l=0.5
X_rhebb_15_8  iwrite_route_15_8  inp_upper_8  ierr_dig_15  vcm_route  vdd vss  hebbian_mult
XMPRED_r_15_9  i_pred_15  vw_route_15_9  vss  vss  sky130_fd_pr__nfet_01v8  w=4  l=0.35
Cw_route_15_9  vw_route_15_9  vss  200f
R_bleed_15_9  vw_route_15_9  vss  10000meg
XMN4_r_15_9  vw_route_15_9  we_route  iwrite_route_15_9  vss  sky130_fd_pr__nfet_01v8  w=0.5  l=0.5
X_rhebb_15_9  iwrite_route_15_9  inp_upper_9  ierr_dig_15  vcm_route  vdd vss  hebbian_mult
XMPRED_r_15_10  i_pred_15  vw_route_15_10  vss  vss  sky130_fd_pr__nfet_01v8  w=4  l=0.35
Cw_route_15_10  vw_route_15_10  vss  200f
R_bleed_15_10  vw_route_15_10  vss  10000meg
XMN4_r_15_10  vw_route_15_10  we_route  iwrite_route_15_10  vss  sky130_fd_pr__nfet_01v8  w=0.5  l=0.5
X_rhebb_15_10  iwrite_route_15_10  inp_upper_10  ierr_dig_15  vcm_route  vdd vss  hebbian_mult
XMPRED_r_15_11  i_pred_15  vw_route_15_11  vss  vss  sky130_fd_pr__nfet_01v8  w=4  l=0.35
Cw_route_15_11  vw_route_15_11  vss  200f
R_bleed_15_11  vw_route_15_11  vss  10000meg
XMN4_r_15_11  vw_route_15_11  we_route  iwrite_route_15_11  vss  sky130_fd_pr__nfet_01v8  w=0.5  l=0.5
X_rhebb_15_11  iwrite_route_15_11  inp_upper_11  ierr_dig_15  vcm_route  vdd vss  hebbian_mult
XMPRED_r_15_12  i_pred_15  vw_route_15_12  vss  vss  sky130_fd_pr__nfet_01v8  w=4  l=0.35
Cw_route_15_12  vw_route_15_12  vss  200f
R_bleed_15_12  vw_route_15_12  vss  10000meg
XMN4_r_15_12  vw_route_15_12  we_route  iwrite_route_15_12  vss  sky130_fd_pr__nfet_01v8  w=0.5  l=0.5
X_rhebb_15_12  iwrite_route_15_12  inp_upper_12  ierr_dig_15  vcm_route  vdd vss  hebbian_mult
XMPRED_r_15_13  i_pred_15  vw_route_15_13  vss  vss  sky130_fd_pr__nfet_01v8  w=4  l=0.35
Cw_route_15_13  vw_route_15_13  vss  200f
R_bleed_15_13  vw_route_15_13  vss  10000meg
XMN4_r_15_13  vw_route_15_13  we_route  iwrite_route_15_13  vss  sky130_fd_pr__nfet_01v8  w=0.5  l=0.5
X_rhebb_15_13  iwrite_route_15_13  inp_upper_13  ierr_dig_15  vcm_route  vdd vss  hebbian_mult
XMPRED_r_15_14  i_pred_15  vw_route_15_14  vss  vss  sky130_fd_pr__nfet_01v8  w=4  l=0.35
Cw_route_15_14  vw_route_15_14  vss  200f
R_bleed_15_14  vw_route_15_14  vss  10000meg
XMN4_r_15_14  vw_route_15_14  we_route  iwrite_route_15_14  vss  sky130_fd_pr__nfet_01v8  w=0.5  l=0.5
X_rhebb_15_14  iwrite_route_15_14  inp_upper_14  ierr_dig_15  vcm_route  vdd vss  hebbian_mult
XMPRED_r_15_15  i_pred_15  vw_route_15_15  vss  vss  sky130_fd_pr__nfet_01v8  w=4  l=0.35
Cw_route_15_15  vw_route_15_15  vss  200f
R_bleed_15_15  vw_route_15_15  vss  10000meg
XMN4_r_15_15  vw_route_15_15  we_route  iwrite_route_15_15  vss  sky130_fd_pr__nfet_01v8  w=0.5  l=0.5
X_rhebb_15_15  iwrite_route_15_15  inp_upper_15  ierr_dig_15  vcm_route  vdd vss  hebbian_mult

.ends layer_link_route_16
