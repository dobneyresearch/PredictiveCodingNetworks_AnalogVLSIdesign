* =============================================================================
* PCN Module — 8-Bit R-2R Activation Input DAC
* File:      inp_dac.spice
* Simulator: ngspice 42+
*
* Converts an 8-bit activation code D[7:0] into an analog voltage Vinp
* that drives the inp node of one column of MAC cells.
*
*   Vinp = Vref × D / 256   (Vref = VDD = 1.8 V)
*
* Activation encoding (with Vref = VDD = 1.8 V):
*   Code   0 (0x00) → Vinp =  0.000 V  (minimum activation)
*   Code 128 (0x80) → Vinp =  0.900 V  (= Vcm; balanced diff-pair input)
*   Code 195 (0xC3) → Vinp =  1.371 V  (representative high activation)
*   Code 255 (0xFF) → Vinp =  1.793 V  (near-maximum activation)
*
* Architecture: identical R-2R ladder to weight_dac.spice.
*   Same resistor values (R=50 kΩ, 2R=100 kΩ) and ideal switch model.
*   Thevenin impedance ≈ R/2 = 25 kΩ.
*
* Settling time to inp node:
*   Single MAC cell: τ = 25 kΩ × 6 fF (MN1 gate cap) ≈ 0.15 ns
*   16-cell column:  τ = 25 kΩ × 96 fF              ≈ 2.4 ns
*   Both are negligible compared to the weight DAC settling (τ=10 ns).
*
* No write-enable: vinp is a continuous analog output.  The DAC code is
* updated by the weight_fsm (inp_dac_we / inp_dac_data) at the start of
* each virtual layer's activation load phase (ST_T_ALOAD).
*
* Port map:  vdd vss vref b7 b6 b5 b4 b3 b2 b1 b0 vinp
*            b7 = MSB (activation weight 128), b0 = LSB (weight 1)
*            Bits are digital signals: 0 V (bit=0) or Vdd (bit=1)
*
* Reference: pred_code_networks.md §56, §57 (inp_dac design)
* =============================================================================

.subckt inp_dac vdd vss vref b7 b6 b5 b4 b3 b2 b1 b0 vinp

* =============================================================================
* SWITCH MODEL  (same as weight_dac.spice)
* =============================================================================
.model sw_hi sw (Ron=100 Roff=1G Vt=0.9 Vh=0.4)

* =============================================================================
* COMPLEMENTARY BIT SIGNALS (B-source arithmetic inverters)
* =============================================================================
Binv7 nb7 0 V = v(vdd) - v(b7)
Binv6 nb6 0 V = v(vdd) - v(b6)
Binv5 nb5 0 V = v(vdd) - v(b5)
Binv4 nb4 0 V = v(vdd) - v(b4)
Binv3 nb3 0 V = v(vdd) - v(b3)
Binv2 nb2 0 V = v(vdd) - v(b2)
Binv1 nb1 0 V = v(vdd) - v(b1)
Binv0 nb0 0 V = v(vdd) - v(b0)

* =============================================================================
* R-2R LADDER NETWORK
* =============================================================================
*   vinp (= n7)
*    │
*    n7─[R]─n6─[R]─n5─[R]─n4─[R]─n3─[R]─n2─[R]─n1─[R]─n0─[2R]─VSS
*    │       │      │      │      │      │      │      │
*   [2R]    [2R]   [2R]   [2R]   [2R]   [2R]   [2R]   [2R]
*    │       │      │      │      │      │      │      │
*   nt7     nt6    nt5    nt4    nt3    nt2    nt1    nt0
*    ├─Vref  ├─Vref ...              (b_k=1)
*    └─VSS   └─VSS  ...              (b_k=0)

Rs7 vinp n6  50000
Rs6  n6  n5  50000
Rs5  n5  n4  50000
Rs4  n4  n3  50000
Rs3  n3  n2  50000
Rs2  n2  n1  50000
Rs1  n1  n0  50000

Rterm n0 vss 100000

Rsh7 vinp nt7 100000
Rsh6  n6  nt6 100000
Rsh5  n5  nt5 100000
Rsh4  n4  nt4 100000
Rsh3  n3  nt3 100000
Rsh2  n2  nt2 100000
Rsh1  n1  nt1 100000
Rsh0  n0  nt0 100000

* =============================================================================
* BIT SWITCHES
* =============================================================================
Sref7 nt7 vref  b7 0 sw_hi
Sgnd7 nt7 vss  nb7 0 sw_hi

Sref6 nt6 vref  b6 0 sw_hi
Sgnd6 nt6 vss  nb6 0 sw_hi

Sref5 nt5 vref  b5 0 sw_hi
Sgnd5 nt5 vss  nb5 0 sw_hi

Sref4 nt4 vref  b4 0 sw_hi
Sgnd4 nt4 vss  nb4 0 sw_hi

Sref3 nt3 vref  b3 0 sw_hi
Sgnd3 nt3 vss  nb3 0 sw_hi

Sref2 nt2 vref  b2 0 sw_hi
Sgnd2 nt2 vss  nb2 0 sw_hi

Sref1 nt1 vref  b1 0 sw_hi
Sgnd1 nt1 vss  nb1 0 sw_hi

Sref0 nt0 vref  b0 0 sw_hi
Sgnd0 nt0 vss  nb0 0 sw_hi

.ends inp_dac
