* Generated by gen_array.py — DO NOT EDIT by hand.
* Regenerate: python3 gen_array.py 32 64
* PCN module: 32×64 array + current_sub + precision_gate for each row.
* Scaling: r_err=6.25k (τ_KCL=28ns), w_mpg=32µm (V_trip≈VDD/2), w_floor=0.5µm (§48 fixed)
*
* Analog signal flow (one column per row r):
*   inp_col_c/inn_col_c → mac array → iout_row_r
*   iout_row_r + i_pred_r → current_sub_r → i_err_r
*   i_err_r → precision_gate_r → ierr_dig_r  (→ digital hebb_ctrl.ierr[r])
*                              ↘ v_post_r    (→ array hebbian_mult)
*
* Ports:
*   inp_col_0..63, inn_col_0..63  — column differential inputs
*   iout_row_0..31 — KCL accumulation bus outputs (exposed for layer_link)
*                        connects to layer_link ascending input and descending gate
*   i_pred_0..31   — prediction current inputs (from layer above via layer_link)
*                        connect as sinking load on i_err node (see current_sub)
*   ierr_dig_0..31 — digital error flags out to hebb_ctrl (HIGH = error > threshold)
*   we_row_0..31   — Hebbian write enables in from hebb_ctrl.we_out
*   vpi_0..31      — precision threshold voltages (one per row; from bias_gen or DAC)
*   vbias_p, vbias_n, vcm — shared bias rails from bias_gen
*   vdd, vss

.subckt pcn_module_32x64
+ inp_col_0 inn_col_0 inp_col_1 inn_col_1 inp_col_2 inn_col_2 inp_col_3 inn_col_3 inp_col_4 inn_col_4 inp_col_5 inn_col_5 inp_col_6 inn_col_6 inp_col_7 inn_col_7 inp_col_8 inn_col_8 inp_col_9 inn_col_9 inp_col_10 inn_col_10 inp_col_11 inn_col_11 inp_col_12 inn_col_12 inp_col_13 inn_col_13 inp_col_14 inn_col_14 inp_col_15 inn_col_15 inp_col_16 inn_col_16 inp_col_17 inn_col_17 inp_col_18 inn_col_18 inp_col_19 inn_col_19 inp_col_20 inn_col_20 inp_col_21 inn_col_21 inp_col_22 inn_col_22 inp_col_23 inn_col_23 inp_col_24 inn_col_24 inp_col_25 inn_col_25 inp_col_26 inn_col_26 inp_col_27 inn_col_27 inp_col_28 inn_col_28 inp_col_29 inn_col_29 inp_col_30 inn_col_30 inp_col_31 inn_col_31 inp_col_32 inn_col_32 inp_col_33 inn_col_33 inp_col_34 inn_col_34 inp_col_35 inn_col_35 inp_col_36 inn_col_36 inp_col_37 inn_col_37 inp_col_38 inn_col_38 inp_col_39 inn_col_39 inp_col_40 inn_col_40 inp_col_41 inn_col_41 inp_col_42 inn_col_42 inp_col_43 inn_col_43 inp_col_44 inn_col_44 inp_col_45 inn_col_45 inp_col_46 inn_col_46 inp_col_47 inn_col_47 inp_col_48 inn_col_48 inp_col_49 inn_col_49 inp_col_50 inn_col_50 inp_col_51 inn_col_51 inp_col_52 inn_col_52 inp_col_53 inn_col_53 inp_col_54 inn_col_54 inp_col_55 inn_col_55 inp_col_56 inn_col_56 inp_col_57 inn_col_57 inp_col_58 inn_col_58 inp_col_59 inn_col_59 inp_col_60 inn_col_60 inp_col_61 inn_col_61 inp_col_62 inn_col_62 inp_col_63 inn_col_63
+ iout_row_0 iout_row_1 iout_row_2 iout_row_3 iout_row_4 iout_row_5 iout_row_6 iout_row_7 iout_row_8 iout_row_9 iout_row_10 iout_row_11 iout_row_12 iout_row_13 iout_row_14 iout_row_15 iout_row_16 iout_row_17 iout_row_18 iout_row_19 iout_row_20 iout_row_21 iout_row_22 iout_row_23 iout_row_24 iout_row_25 iout_row_26 iout_row_27 iout_row_28 iout_row_29 iout_row_30 iout_row_31
+ i_pred_0 i_pred_1 i_pred_2 i_pred_3 i_pred_4 i_pred_5 i_pred_6 i_pred_7 i_pred_8 i_pred_9 i_pred_10 i_pred_11 i_pred_12 i_pred_13 i_pred_14 i_pred_15 i_pred_16 i_pred_17 i_pred_18 i_pred_19 i_pred_20 i_pred_21 i_pred_22 i_pred_23 i_pred_24 i_pred_25 i_pred_26 i_pred_27 i_pred_28 i_pred_29 i_pred_30 i_pred_31
+ ierr_dig_0 ierr_dig_1 ierr_dig_2 ierr_dig_3 ierr_dig_4 ierr_dig_5 ierr_dig_6 ierr_dig_7 ierr_dig_8 ierr_dig_9 ierr_dig_10 ierr_dig_11 ierr_dig_12 ierr_dig_13 ierr_dig_14 ierr_dig_15 ierr_dig_16 ierr_dig_17 ierr_dig_18 ierr_dig_19 ierr_dig_20 ierr_dig_21 ierr_dig_22 ierr_dig_23 ierr_dig_24 ierr_dig_25 ierr_dig_26 ierr_dig_27 ierr_dig_28 ierr_dig_29 ierr_dig_30 ierr_dig_31
+ we_row_0 we_row_1 we_row_2 we_row_3 we_row_4 we_row_5 we_row_6 we_row_7 we_row_8 we_row_9 we_row_10 we_row_11 we_row_12 we_row_13 we_row_14 we_row_15 we_row_16 we_row_17 we_row_18 we_row_19 we_row_20 we_row_21 we_row_22 we_row_23 we_row_24 we_row_25 we_row_26 we_row_27 we_row_28 we_row_29 we_row_30 we_row_31
+ vpi_0 vpi_1 vpi_2 vpi_3 vpi_4 vpi_5 vpi_6 vpi_7 vpi_8 vpi_9 vpi_10 vpi_11 vpi_12 vpi_13 vpi_14 vpi_15 vpi_16 vpi_17 vpi_18 vpi_19 vpi_20 vpi_21 vpi_22 vpi_23 vpi_24 vpi_25 vpi_26 vpi_27 vpi_28 vpi_29 vpi_30 vpi_31
+ vbias_p vbias_n vcm vdd vss

* ── Array instance ───────────────────────────────────────────────────────────
Xarray
+ inp_col_0 inn_col_0 inp_col_1 inn_col_1 inp_col_2 inn_col_2 inp_col_3 inn_col_3 inp_col_4 inn_col_4 inp_col_5 inn_col_5 inp_col_6 inn_col_6 inp_col_7 inn_col_7 inp_col_8 inn_col_8 inp_col_9 inn_col_9 inp_col_10 inn_col_10 inp_col_11 inn_col_11 inp_col_12 inn_col_12 inp_col_13 inn_col_13 inp_col_14 inn_col_14 inp_col_15 inn_col_15 inp_col_16 inn_col_16 inp_col_17 inn_col_17 inp_col_18 inn_col_18 inp_col_19 inn_col_19 inp_col_20 inn_col_20 inp_col_21 inn_col_21 inp_col_22 inn_col_22 inp_col_23 inn_col_23 inp_col_24 inn_col_24 inp_col_25 inn_col_25 inp_col_26 inn_col_26 inp_col_27 inn_col_27 inp_col_28 inn_col_28 inp_col_29 inn_col_29 inp_col_30 inn_col_30 inp_col_31 inn_col_31 inp_col_32 inn_col_32 inp_col_33 inn_col_33 inp_col_34 inn_col_34 inp_col_35 inn_col_35 inp_col_36 inn_col_36 inp_col_37 inn_col_37 inp_col_38 inn_col_38 inp_col_39 inn_col_39 inp_col_40 inn_col_40 inp_col_41 inn_col_41 inp_col_42 inn_col_42 inp_col_43 inn_col_43 inp_col_44 inn_col_44 inp_col_45 inn_col_45 inp_col_46 inn_col_46 inp_col_47 inn_col_47 inp_col_48 inn_col_48 inp_col_49 inn_col_49 inp_col_50 inn_col_50 inp_col_51 inn_col_51 inp_col_52 inn_col_52 inp_col_53 inn_col_53 inp_col_54 inn_col_54 inp_col_55 inn_col_55 inp_col_56 inn_col_56 inp_col_57 inn_col_57 inp_col_58 inn_col_58 inp_col_59 inn_col_59 inp_col_60 inn_col_60 inp_col_61 inn_col_61 inp_col_62 inn_col_62 inp_col_63 inn_col_63
+ iout_row_0 iout_row_1 iout_row_2 iout_row_3 iout_row_4 iout_row_5 iout_row_6 iout_row_7 iout_row_8 iout_row_9 iout_row_10 iout_row_11 iout_row_12 iout_row_13 iout_row_14 iout_row_15 iout_row_16 iout_row_17 iout_row_18 iout_row_19 iout_row_20 iout_row_21 iout_row_22 iout_row_23 iout_row_24 iout_row_25 iout_row_26 iout_row_27 iout_row_28 iout_row_29 iout_row_30 iout_row_31
+ we_row_0 we_row_1 we_row_2 we_row_3 we_row_4 we_row_5 we_row_6 we_row_7 we_row_8 we_row_9 we_row_10 we_row_11 we_row_12 we_row_13 we_row_14 we_row_15 we_row_16 we_row_17 we_row_18 we_row_19 we_row_20 we_row_21 we_row_22 we_row_23 we_row_24 we_row_25 we_row_26 we_row_27 we_row_28 we_row_29 we_row_30 we_row_31
+ ierr_dig_0 ierr_dig_1 ierr_dig_2 ierr_dig_3 ierr_dig_4 ierr_dig_5 ierr_dig_6 ierr_dig_7 ierr_dig_8 ierr_dig_9 ierr_dig_10 ierr_dig_11 ierr_dig_12 ierr_dig_13 ierr_dig_14 ierr_dig_15 ierr_dig_16 ierr_dig_17 ierr_dig_18 ierr_dig_19 ierr_dig_20 ierr_dig_21 ierr_dig_22 ierr_dig_23 ierr_dig_24 ierr_dig_25 ierr_dig_26 ierr_dig_27 ierr_dig_28 ierr_dig_29 ierr_dig_30 ierr_dig_31
+ vcm vdd vss
+ pcn_array_32x64

* ── current_sub: one per row ─────────────────────────────────────────────────
* X_csub_r  i_actual=iout_row_r  i_pred=i_pred_r  i_err=i_err_r  vdd vss  r_err=6.25k
X_csub_0  iout_row_0  i_pred_0  i_err_0  vdd vss  current_sub  r_err=6.25k
X_csub_1  iout_row_1  i_pred_1  i_err_1  vdd vss  current_sub  r_err=6.25k
X_csub_2  iout_row_2  i_pred_2  i_err_2  vdd vss  current_sub  r_err=6.25k
X_csub_3  iout_row_3  i_pred_3  i_err_3  vdd vss  current_sub  r_err=6.25k
X_csub_4  iout_row_4  i_pred_4  i_err_4  vdd vss  current_sub  r_err=6.25k
X_csub_5  iout_row_5  i_pred_5  i_err_5  vdd vss  current_sub  r_err=6.25k
X_csub_6  iout_row_6  i_pred_6  i_err_6  vdd vss  current_sub  r_err=6.25k
X_csub_7  iout_row_7  i_pred_7  i_err_7  vdd vss  current_sub  r_err=6.25k
X_csub_8  iout_row_8  i_pred_8  i_err_8  vdd vss  current_sub  r_err=6.25k
X_csub_9  iout_row_9  i_pred_9  i_err_9  vdd vss  current_sub  r_err=6.25k
X_csub_10  iout_row_10  i_pred_10  i_err_10  vdd vss  current_sub  r_err=6.25k
X_csub_11  iout_row_11  i_pred_11  i_err_11  vdd vss  current_sub  r_err=6.25k
X_csub_12  iout_row_12  i_pred_12  i_err_12  vdd vss  current_sub  r_err=6.25k
X_csub_13  iout_row_13  i_pred_13  i_err_13  vdd vss  current_sub  r_err=6.25k
X_csub_14  iout_row_14  i_pred_14  i_err_14  vdd vss  current_sub  r_err=6.25k
X_csub_15  iout_row_15  i_pred_15  i_err_15  vdd vss  current_sub  r_err=6.25k
X_csub_16  iout_row_16  i_pred_16  i_err_16  vdd vss  current_sub  r_err=6.25k
X_csub_17  iout_row_17  i_pred_17  i_err_17  vdd vss  current_sub  r_err=6.25k
X_csub_18  iout_row_18  i_pred_18  i_err_18  vdd vss  current_sub  r_err=6.25k
X_csub_19  iout_row_19  i_pred_19  i_err_19  vdd vss  current_sub  r_err=6.25k
X_csub_20  iout_row_20  i_pred_20  i_err_20  vdd vss  current_sub  r_err=6.25k
X_csub_21  iout_row_21  i_pred_21  i_err_21  vdd vss  current_sub  r_err=6.25k
X_csub_22  iout_row_22  i_pred_22  i_err_22  vdd vss  current_sub  r_err=6.25k
X_csub_23  iout_row_23  i_pred_23  i_err_23  vdd vss  current_sub  r_err=6.25k
X_csub_24  iout_row_24  i_pred_24  i_err_24  vdd vss  current_sub  r_err=6.25k
X_csub_25  iout_row_25  i_pred_25  i_err_25  vdd vss  current_sub  r_err=6.25k
X_csub_26  iout_row_26  i_pred_26  i_err_26  vdd vss  current_sub  r_err=6.25k
X_csub_27  iout_row_27  i_pred_27  i_err_27  vdd vss  current_sub  r_err=6.25k
X_csub_28  iout_row_28  i_pred_28  i_err_28  vdd vss  current_sub  r_err=6.25k
X_csub_29  iout_row_29  i_pred_29  i_err_29  vdd vss  current_sub  r_err=6.25k
X_csub_30  iout_row_30  i_pred_30  i_err_30  vdd vss  current_sub  r_err=6.25k
X_csub_31  iout_row_31  i_pred_31  i_err_31  vdd vss  current_sub  r_err=6.25k

* ── precision_gate: one per row ──────────────────────────────────────────────
* X_pgate_r  i_in=i_err_r  vpi=vpi_r  i_out=i_pout_r  ierr_dig=ierr_dig_r  vdd vss
*            w_mpg=32µm  w_floor=0.5µm
X_pgate_0  i_err_0  vpi_0  i_pout_0  ierr_dig_0  vdd vss  precision_gate  w_mpg=32  w_floor=0.5
X_pgate_1  i_err_1  vpi_1  i_pout_1  ierr_dig_1  vdd vss  precision_gate  w_mpg=32  w_floor=0.5
X_pgate_2  i_err_2  vpi_2  i_pout_2  ierr_dig_2  vdd vss  precision_gate  w_mpg=32  w_floor=0.5
X_pgate_3  i_err_3  vpi_3  i_pout_3  ierr_dig_3  vdd vss  precision_gate  w_mpg=32  w_floor=0.5
X_pgate_4  i_err_4  vpi_4  i_pout_4  ierr_dig_4  vdd vss  precision_gate  w_mpg=32  w_floor=0.5
X_pgate_5  i_err_5  vpi_5  i_pout_5  ierr_dig_5  vdd vss  precision_gate  w_mpg=32  w_floor=0.5
X_pgate_6  i_err_6  vpi_6  i_pout_6  ierr_dig_6  vdd vss  precision_gate  w_mpg=32  w_floor=0.5
X_pgate_7  i_err_7  vpi_7  i_pout_7  ierr_dig_7  vdd vss  precision_gate  w_mpg=32  w_floor=0.5
X_pgate_8  i_err_8  vpi_8  i_pout_8  ierr_dig_8  vdd vss  precision_gate  w_mpg=32  w_floor=0.5
X_pgate_9  i_err_9  vpi_9  i_pout_9  ierr_dig_9  vdd vss  precision_gate  w_mpg=32  w_floor=0.5
X_pgate_10  i_err_10  vpi_10  i_pout_10  ierr_dig_10  vdd vss  precision_gate  w_mpg=32  w_floor=0.5
X_pgate_11  i_err_11  vpi_11  i_pout_11  ierr_dig_11  vdd vss  precision_gate  w_mpg=32  w_floor=0.5
X_pgate_12  i_err_12  vpi_12  i_pout_12  ierr_dig_12  vdd vss  precision_gate  w_mpg=32  w_floor=0.5
X_pgate_13  i_err_13  vpi_13  i_pout_13  ierr_dig_13  vdd vss  precision_gate  w_mpg=32  w_floor=0.5
X_pgate_14  i_err_14  vpi_14  i_pout_14  ierr_dig_14  vdd vss  precision_gate  w_mpg=32  w_floor=0.5
X_pgate_15  i_err_15  vpi_15  i_pout_15  ierr_dig_15  vdd vss  precision_gate  w_mpg=32  w_floor=0.5
X_pgate_16  i_err_16  vpi_16  i_pout_16  ierr_dig_16  vdd vss  precision_gate  w_mpg=32  w_floor=0.5
X_pgate_17  i_err_17  vpi_17  i_pout_17  ierr_dig_17  vdd vss  precision_gate  w_mpg=32  w_floor=0.5
X_pgate_18  i_err_18  vpi_18  i_pout_18  ierr_dig_18  vdd vss  precision_gate  w_mpg=32  w_floor=0.5
X_pgate_19  i_err_19  vpi_19  i_pout_19  ierr_dig_19  vdd vss  precision_gate  w_mpg=32  w_floor=0.5
X_pgate_20  i_err_20  vpi_20  i_pout_20  ierr_dig_20  vdd vss  precision_gate  w_mpg=32  w_floor=0.5
X_pgate_21  i_err_21  vpi_21  i_pout_21  ierr_dig_21  vdd vss  precision_gate  w_mpg=32  w_floor=0.5
X_pgate_22  i_err_22  vpi_22  i_pout_22  ierr_dig_22  vdd vss  precision_gate  w_mpg=32  w_floor=0.5
X_pgate_23  i_err_23  vpi_23  i_pout_23  ierr_dig_23  vdd vss  precision_gate  w_mpg=32  w_floor=0.5
X_pgate_24  i_err_24  vpi_24  i_pout_24  ierr_dig_24  vdd vss  precision_gate  w_mpg=32  w_floor=0.5
X_pgate_25  i_err_25  vpi_25  i_pout_25  ierr_dig_25  vdd vss  precision_gate  w_mpg=32  w_floor=0.5
X_pgate_26  i_err_26  vpi_26  i_pout_26  ierr_dig_26  vdd vss  precision_gate  w_mpg=32  w_floor=0.5
X_pgate_27  i_err_27  vpi_27  i_pout_27  ierr_dig_27  vdd vss  precision_gate  w_mpg=32  w_floor=0.5
X_pgate_28  i_err_28  vpi_28  i_pout_28  ierr_dig_28  vdd vss  precision_gate  w_mpg=32  w_floor=0.5
X_pgate_29  i_err_29  vpi_29  i_pout_29  ierr_dig_29  vdd vss  precision_gate  w_mpg=32  w_floor=0.5
X_pgate_30  i_err_30  vpi_30  i_pout_30  ierr_dig_30  vdd vss  precision_gate  w_mpg=32  w_floor=0.5
X_pgate_31  i_err_31  vpi_31  i_pout_31  ierr_dig_31  vdd vss  precision_gate  w_mpg=32  w_floor=0.5

.ends pcn_module_32x64
