* Generated by gen_array.py — DO NOT EDIT by hand.
* Regenerate: python3 gen_array.py 4 4
* PCN weight array: 4 rows × 4 columns = 16 MAC cells.
*
* Port convention:
*   inp_col_c / inn_col_c  — differential column inputs (c = 0..3)
*   iout_row_r             — row KCL accumulation bus (r = 0..3)
*   we_row_r               — Hebbian write enable for row r (from hebb_ctrl)
*   v_post_r               — post-synaptic signal for row r (from precision_gate.ierr_dig)
*   vcm vdd vss
*
* Internal nodes:
*   vw_r_c                 — weight capacitor voltage for cell [r][c]
*   iwrite_r_c             — Hebbian update current (hebbian_mult → mac_cell.iwrite)

.subckt pcn_array_4x4
+ inp_col_0 inn_col_0 inp_col_1 inn_col_1 inp_col_2 inn_col_2 inp_col_3 inn_col_3
+ iout_row_0 iout_row_1 iout_row_2 iout_row_3
+ we_row_0 we_row_1 we_row_2 we_row_3
+ v_post_0 v_post_1 v_post_2 v_post_3
+ vcm vdd vss

* ── MAC cells ────────────────────────────────────────────────────────────────
* X_mac_r_c  iout_row_r  inp_col_c  inn_col_c  vw_r_c  iwrite_r_c  we_row_r  vdd vss  mac_cell
X_mac_0_0  iout_row_0  inp_col_0  inn_col_0  vw_0_0  iwrite_0_0  we_row_0  vdd vss  mac_cell
X_mac_0_1  iout_row_0  inp_col_1  inn_col_1  vw_0_1  iwrite_0_1  we_row_0  vdd vss  mac_cell
X_mac_0_2  iout_row_0  inp_col_2  inn_col_2  vw_0_2  iwrite_0_2  we_row_0  vdd vss  mac_cell
X_mac_0_3  iout_row_0  inp_col_3  inn_col_3  vw_0_3  iwrite_0_3  we_row_0  vdd vss  mac_cell

X_mac_1_0  iout_row_1  inp_col_0  inn_col_0  vw_1_0  iwrite_1_0  we_row_1  vdd vss  mac_cell
X_mac_1_1  iout_row_1  inp_col_1  inn_col_1  vw_1_1  iwrite_1_1  we_row_1  vdd vss  mac_cell
X_mac_1_2  iout_row_1  inp_col_2  inn_col_2  vw_1_2  iwrite_1_2  we_row_1  vdd vss  mac_cell
X_mac_1_3  iout_row_1  inp_col_3  inn_col_3  vw_1_3  iwrite_1_3  we_row_1  vdd vss  mac_cell

X_mac_2_0  iout_row_2  inp_col_0  inn_col_0  vw_2_0  iwrite_2_0  we_row_2  vdd vss  mac_cell
X_mac_2_1  iout_row_2  inp_col_1  inn_col_1  vw_2_1  iwrite_2_1  we_row_2  vdd vss  mac_cell
X_mac_2_2  iout_row_2  inp_col_2  inn_col_2  vw_2_2  iwrite_2_2  we_row_2  vdd vss  mac_cell
X_mac_2_3  iout_row_2  inp_col_3  inn_col_3  vw_2_3  iwrite_2_3  we_row_2  vdd vss  mac_cell

X_mac_3_0  iout_row_3  inp_col_0  inn_col_0  vw_3_0  iwrite_3_0  we_row_3  vdd vss  mac_cell
X_mac_3_1  iout_row_3  inp_col_1  inn_col_1  vw_3_1  iwrite_3_1  we_row_3  vdd vss  mac_cell
X_mac_3_2  iout_row_3  inp_col_2  inn_col_2  vw_3_2  iwrite_3_2  we_row_3  vdd vss  mac_cell
X_mac_3_3  iout_row_3  inp_col_3  inn_col_3  vw_3_3  iwrite_3_3  we_row_3  vdd vss  mac_cell

* ── Hebbian multipliers ──────────────────────────────────────────────────────
* X_hebb_r_c  iwrite_r_c  v_pre(=inp_col_c)  v_post_r  vcm  vdd vss  hebbian_mult
X_hebb_0_0  iwrite_0_0  inp_col_0  v_post_0  vcm vdd vss  hebbian_mult
X_hebb_0_1  iwrite_0_1  inp_col_1  v_post_0  vcm vdd vss  hebbian_mult
X_hebb_0_2  iwrite_0_2  inp_col_2  v_post_0  vcm vdd vss  hebbian_mult
X_hebb_0_3  iwrite_0_3  inp_col_3  v_post_0  vcm vdd vss  hebbian_mult

X_hebb_1_0  iwrite_1_0  inp_col_0  v_post_1  vcm vdd vss  hebbian_mult
X_hebb_1_1  iwrite_1_1  inp_col_1  v_post_1  vcm vdd vss  hebbian_mult
X_hebb_1_2  iwrite_1_2  inp_col_2  v_post_1  vcm vdd vss  hebbian_mult
X_hebb_1_3  iwrite_1_3  inp_col_3  v_post_1  vcm vdd vss  hebbian_mult

X_hebb_2_0  iwrite_2_0  inp_col_0  v_post_2  vcm vdd vss  hebbian_mult
X_hebb_2_1  iwrite_2_1  inp_col_1  v_post_2  vcm vdd vss  hebbian_mult
X_hebb_2_2  iwrite_2_2  inp_col_2  v_post_2  vcm vdd vss  hebbian_mult
X_hebb_2_3  iwrite_2_3  inp_col_3  v_post_2  vcm vdd vss  hebbian_mult

X_hebb_3_0  iwrite_3_0  inp_col_0  v_post_3  vcm vdd vss  hebbian_mult
X_hebb_3_1  iwrite_3_1  inp_col_1  v_post_3  vcm vdd vss  hebbian_mult
X_hebb_3_2  iwrite_3_2  inp_col_2  v_post_3  vcm vdd vss  hebbian_mult
X_hebb_3_3  iwrite_3_3  inp_col_3  v_post_3  vcm vdd vss  hebbian_mult

.ends pcn_array_4x4
