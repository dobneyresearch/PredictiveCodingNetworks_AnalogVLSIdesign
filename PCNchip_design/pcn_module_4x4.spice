* Generated by gen_array.py — DO NOT EDIT by hand.
* Regenerate: python3 gen_array.py 4 4
* PCN module: 4×4 array + current_sub + precision_gate for each row.
* Scaling: r_err=100k (τ_KCL=28ns), w_mpg=2µm (V_trip≈VDD/2), w_floor=0.5µm (§48 fixed)
*
* Analog signal flow (one column per row r):
*   inp_col_c/inn_col_c → mac array → iout_row_r
*   iout_row_r + i_pred_r → current_sub_r → i_err_r
*   i_err_r → precision_gate_r → ierr_dig_r  (→ digital hebb_ctrl.ierr[r])
*                              ↘ v_post_r    (→ array hebbian_mult)
*
* Ports:
*   inp_col_0..3, inn_col_0..3  — column differential inputs
*   iout_row_0..3 — KCL accumulation bus outputs (exposed for layer_link)
*                        connects to layer_link ascending input and descending gate
*   i_pred_0..3   — prediction current inputs (from layer above via layer_link)
*                        connect as sinking load on i_err node (see current_sub)
*   ierr_dig_0..3 — digital error flags out to hebb_ctrl (HIGH = error > threshold)
*   we_row_0..3   — Hebbian write enables in from hebb_ctrl.we_out
*   vpi_0..3      — precision threshold voltages (one per row; from bias_gen or DAC)
*   vbias_p, vbias_n, vcm — shared bias rails from bias_gen
*   vdd, vss

.subckt pcn_module_4x4
+ inp_col_0 inn_col_0 inp_col_1 inn_col_1 inp_col_2 inn_col_2 inp_col_3 inn_col_3
+ iout_row_0 iout_row_1 iout_row_2 iout_row_3
+ i_pred_0 i_pred_1 i_pred_2 i_pred_3
+ ierr_dig_0 ierr_dig_1 ierr_dig_2 ierr_dig_3
+ we_row_0 we_row_1 we_row_2 we_row_3
+ vpi_0 vpi_1 vpi_2 vpi_3
+ vbias_p vbias_n vcm vdd vss

* ── Array instance ───────────────────────────────────────────────────────────
Xarray
+ inp_col_0 inn_col_0 inp_col_1 inn_col_1 inp_col_2 inn_col_2 inp_col_3 inn_col_3
+ iout_row_0 iout_row_1 iout_row_2 iout_row_3
+ we_row_0 we_row_1 we_row_2 we_row_3
+ ierr_dig_0 ierr_dig_1 ierr_dig_2 ierr_dig_3
+ vcm vdd vss
+ pcn_array_4x4

* ── current_sub: one per row ─────────────────────────────────────────────────
* X_csub_r  i_actual=iout_row_r  i_pred=i_pred_r  i_err=i_err_r  vdd vss  r_err=100k
X_csub_0  iout_row_0  i_pred_0  i_err_0  vdd vss  current_sub  r_err=100k
X_csub_1  iout_row_1  i_pred_1  i_err_1  vdd vss  current_sub  r_err=100k
X_csub_2  iout_row_2  i_pred_2  i_err_2  vdd vss  current_sub  r_err=100k
X_csub_3  iout_row_3  i_pred_3  i_err_3  vdd vss  current_sub  r_err=100k

* ── precision_gate: one per row ──────────────────────────────────────────────
* X_pgate_r  i_in=i_err_r  vpi=vpi_r  i_out=i_pout_r  ierr_dig=ierr_dig_r  vdd vss
*            w_mpg=2µm  w_floor=0.5µm
X_pgate_0  i_err_0  vpi_0  i_pout_0  ierr_dig_0  vdd vss  precision_gate  w_mpg=2  w_floor=0.5
X_pgate_1  i_err_1  vpi_1  i_pout_1  ierr_dig_1  vdd vss  precision_gate  w_mpg=2  w_floor=0.5
X_pgate_2  i_err_2  vpi_2  i_pout_2  ierr_dig_2  vdd vss  precision_gate  w_mpg=2  w_floor=0.5
X_pgate_3  i_err_3  vpi_3  i_pout_3  ierr_dig_3  vdd vss  precision_gate  w_mpg=2  w_floor=0.5

.ends pcn_module_4x4
