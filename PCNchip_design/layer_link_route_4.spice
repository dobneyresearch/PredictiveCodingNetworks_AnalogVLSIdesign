* Generated by gen_array.py — DO NOT EDIT by hand.
* Regenerate: python3 gen_array.py --routing 4
* Routing layer link: 4 ascending SFs + 4×4 routing matrix.
* Routing cells: 16 XMPRED + 16 Cw_route + 16 MN4_r + 16 hebbian_mult
*
* See pred_code_networks.md §42 for design rationale.

.subckt layer_link_route_4
+ iout_lower_0  iout_lower_1  iout_lower_2  iout_lower_3
+ inp_upper_0  inp_upper_1  inp_upper_2  inp_upper_3
+ i_pred_0  i_pred_1  i_pred_2  i_pred_3
+ iout_upper_0  iout_upper_1  iout_upper_2  iout_upper_3
+ ierr_dig_0  ierr_dig_1  ierr_dig_2  ierr_dig_3
+ we_route
+ vcm_route vcm_upper vcm_iout vbias_n vdd vss

* ──────────────────────────────────────────────────────────────────────────
* ASCENDING PATH: 4 PMOS source followers  iout_lower_r → inp_upper_r
* V(inp_upper) = V(iout_lower) + |Vgs_P| ≈ +0.65V (§71 PMOS SF fix)
* ──────────────────────────────────────────────────────────────────────────
* Row 0
XMSF_0   n_sf_d_0  iout_lower_0  inp_upper_0  vdd   sky130_fd_pr__pfet_01v8  w=4  l=0.5
XMTAIL_0  n_sf_d_0  vbias_n  vss  vss   sky130_fd_pr__nfet_01v8  w=2  l=1
* Row 1
XMSF_1   n_sf_d_1  iout_lower_1  inp_upper_1  vdd   sky130_fd_pr__pfet_01v8  w=4  l=0.5
XMTAIL_1  n_sf_d_1  vbias_n  vss  vss   sky130_fd_pr__nfet_01v8  w=2  l=1
* Row 2
XMSF_2   n_sf_d_2  iout_lower_2  inp_upper_2  vdd   sky130_fd_pr__pfet_01v8  w=4  l=0.5
XMTAIL_2  n_sf_d_2  vbias_n  vss  vss   sky130_fd_pr__nfet_01v8  w=2  l=1
* Row 3
XMSF_3   n_sf_d_3  iout_lower_3  inp_upper_3  vdd   sky130_fd_pr__pfet_01v8  w=4  l=0.5
XMTAIL_3  n_sf_d_3  vbias_n  vss  vss   sky130_fd_pr__nfet_01v8  w=2  l=1
* Reference PMOS SF: vcm_iout → vcm_upper (matched shift for inn_col; §72 fix)
XMSF_ref   n_sfref_d  vcm_iout  vcm_upper  vdd   sky130_fd_pr__pfet_01v8  w=4  l=0.5
XMTAIL_ref n_sfref_d  vbias_n  vss  vss   sky130_fd_pr__nfet_01v8  w=2  l=1

* ──────────────────────────────────────────────────────────────────────────
* DESCENDING ROUTING MATRIX: 4×4 = 16 routing cells
*
* For each (dest=d, src=s):
*   XMPRED_r_d_s  — NMOS sinking from i_pred_d; gate=Vw_route_d_s
*   Cw_route_d_s  — 200fF routing weight capacitor (increase to 2p for
*                   10× slower topology timescale vs MAC weights)
*   MN4_r_d_s     — access transistor; gate=we_route
*   X_rhebb_d_s   — hebbian_mult: v_pre=inp_upper_s, vcm=vcm_route, v_post=ierr_dig_d
*                   updates Cw_route when source active AND dest has error
* ──────────────────────────────────────────────────────────────────────────

* ── Destination row 0 ── 4 source connections ──────────────────────────
XMPRED_r_0_0  i_pred_0  vw_route_0_0  vss  vss  sky130_fd_pr__nfet_01v8  w=4  l=0.35
Cw_route_0_0  vw_route_0_0  vss  200f
R_bleed_0_0  vw_route_0_0  vss  10000meg
XMN4_r_0_0  vw_route_0_0  we_route  iwrite_route_0_0  vss  sky130_fd_pr__nfet_01v8  w=0.5  l=0.5
X_rhebb_0_0  iwrite_route_0_0  inp_upper_0  ierr_dig_0  vcm_route  vdd vss  hebbian_mult
XMPRED_r_0_1  i_pred_0  vw_route_0_1  vss  vss  sky130_fd_pr__nfet_01v8  w=4  l=0.35
Cw_route_0_1  vw_route_0_1  vss  200f
R_bleed_0_1  vw_route_0_1  vss  10000meg
XMN4_r_0_1  vw_route_0_1  we_route  iwrite_route_0_1  vss  sky130_fd_pr__nfet_01v8  w=0.5  l=0.5
X_rhebb_0_1  iwrite_route_0_1  inp_upper_1  ierr_dig_0  vcm_route  vdd vss  hebbian_mult
XMPRED_r_0_2  i_pred_0  vw_route_0_2  vss  vss  sky130_fd_pr__nfet_01v8  w=4  l=0.35
Cw_route_0_2  vw_route_0_2  vss  200f
R_bleed_0_2  vw_route_0_2  vss  10000meg
XMN4_r_0_2  vw_route_0_2  we_route  iwrite_route_0_2  vss  sky130_fd_pr__nfet_01v8  w=0.5  l=0.5
X_rhebb_0_2  iwrite_route_0_2  inp_upper_2  ierr_dig_0  vcm_route  vdd vss  hebbian_mult
XMPRED_r_0_3  i_pred_0  vw_route_0_3  vss  vss  sky130_fd_pr__nfet_01v8  w=4  l=0.35
Cw_route_0_3  vw_route_0_3  vss  200f
R_bleed_0_3  vw_route_0_3  vss  10000meg
XMN4_r_0_3  vw_route_0_3  we_route  iwrite_route_0_3  vss  sky130_fd_pr__nfet_01v8  w=0.5  l=0.5
X_rhebb_0_3  iwrite_route_0_3  inp_upper_3  ierr_dig_0  vcm_route  vdd vss  hebbian_mult

* ── Destination row 1 ── 4 source connections ──────────────────────────
XMPRED_r_1_0  i_pred_1  vw_route_1_0  vss  vss  sky130_fd_pr__nfet_01v8  w=4  l=0.35
Cw_route_1_0  vw_route_1_0  vss  200f
R_bleed_1_0  vw_route_1_0  vss  10000meg
XMN4_r_1_0  vw_route_1_0  we_route  iwrite_route_1_0  vss  sky130_fd_pr__nfet_01v8  w=0.5  l=0.5
X_rhebb_1_0  iwrite_route_1_0  inp_upper_0  ierr_dig_1  vcm_route  vdd vss  hebbian_mult
XMPRED_r_1_1  i_pred_1  vw_route_1_1  vss  vss  sky130_fd_pr__nfet_01v8  w=4  l=0.35
Cw_route_1_1  vw_route_1_1  vss  200f
R_bleed_1_1  vw_route_1_1  vss  10000meg
XMN4_r_1_1  vw_route_1_1  we_route  iwrite_route_1_1  vss  sky130_fd_pr__nfet_01v8  w=0.5  l=0.5
X_rhebb_1_1  iwrite_route_1_1  inp_upper_1  ierr_dig_1  vcm_route  vdd vss  hebbian_mult
XMPRED_r_1_2  i_pred_1  vw_route_1_2  vss  vss  sky130_fd_pr__nfet_01v8  w=4  l=0.35
Cw_route_1_2  vw_route_1_2  vss  200f
R_bleed_1_2  vw_route_1_2  vss  10000meg
XMN4_r_1_2  vw_route_1_2  we_route  iwrite_route_1_2  vss  sky130_fd_pr__nfet_01v8  w=0.5  l=0.5
X_rhebb_1_2  iwrite_route_1_2  inp_upper_2  ierr_dig_1  vcm_route  vdd vss  hebbian_mult
XMPRED_r_1_3  i_pred_1  vw_route_1_3  vss  vss  sky130_fd_pr__nfet_01v8  w=4  l=0.35
Cw_route_1_3  vw_route_1_3  vss  200f
R_bleed_1_3  vw_route_1_3  vss  10000meg
XMN4_r_1_3  vw_route_1_3  we_route  iwrite_route_1_3  vss  sky130_fd_pr__nfet_01v8  w=0.5  l=0.5
X_rhebb_1_3  iwrite_route_1_3  inp_upper_3  ierr_dig_1  vcm_route  vdd vss  hebbian_mult

* ── Destination row 2 ── 4 source connections ──────────────────────────
XMPRED_r_2_0  i_pred_2  vw_route_2_0  vss  vss  sky130_fd_pr__nfet_01v8  w=4  l=0.35
Cw_route_2_0  vw_route_2_0  vss  200f
R_bleed_2_0  vw_route_2_0  vss  10000meg
XMN4_r_2_0  vw_route_2_0  we_route  iwrite_route_2_0  vss  sky130_fd_pr__nfet_01v8  w=0.5  l=0.5
X_rhebb_2_0  iwrite_route_2_0  inp_upper_0  ierr_dig_2  vcm_route  vdd vss  hebbian_mult
XMPRED_r_2_1  i_pred_2  vw_route_2_1  vss  vss  sky130_fd_pr__nfet_01v8  w=4  l=0.35
Cw_route_2_1  vw_route_2_1  vss  200f
R_bleed_2_1  vw_route_2_1  vss  10000meg
XMN4_r_2_1  vw_route_2_1  we_route  iwrite_route_2_1  vss  sky130_fd_pr__nfet_01v8  w=0.5  l=0.5
X_rhebb_2_1  iwrite_route_2_1  inp_upper_1  ierr_dig_2  vcm_route  vdd vss  hebbian_mult
XMPRED_r_2_2  i_pred_2  vw_route_2_2  vss  vss  sky130_fd_pr__nfet_01v8  w=4  l=0.35
Cw_route_2_2  vw_route_2_2  vss  200f
R_bleed_2_2  vw_route_2_2  vss  10000meg
XMN4_r_2_2  vw_route_2_2  we_route  iwrite_route_2_2  vss  sky130_fd_pr__nfet_01v8  w=0.5  l=0.5
X_rhebb_2_2  iwrite_route_2_2  inp_upper_2  ierr_dig_2  vcm_route  vdd vss  hebbian_mult
XMPRED_r_2_3  i_pred_2  vw_route_2_3  vss  vss  sky130_fd_pr__nfet_01v8  w=4  l=0.35
Cw_route_2_3  vw_route_2_3  vss  200f
R_bleed_2_3  vw_route_2_3  vss  10000meg
XMN4_r_2_3  vw_route_2_3  we_route  iwrite_route_2_3  vss  sky130_fd_pr__nfet_01v8  w=0.5  l=0.5
X_rhebb_2_3  iwrite_route_2_3  inp_upper_3  ierr_dig_2  vcm_route  vdd vss  hebbian_mult

* ── Destination row 3 ── 4 source connections ──────────────────────────
XMPRED_r_3_0  i_pred_3  vw_route_3_0  vss  vss  sky130_fd_pr__nfet_01v8  w=4  l=0.35
Cw_route_3_0  vw_route_3_0  vss  200f
R_bleed_3_0  vw_route_3_0  vss  10000meg
XMN4_r_3_0  vw_route_3_0  we_route  iwrite_route_3_0  vss  sky130_fd_pr__nfet_01v8  w=0.5  l=0.5
X_rhebb_3_0  iwrite_route_3_0  inp_upper_0  ierr_dig_3  vcm_route  vdd vss  hebbian_mult
XMPRED_r_3_1  i_pred_3  vw_route_3_1  vss  vss  sky130_fd_pr__nfet_01v8  w=4  l=0.35
Cw_route_3_1  vw_route_3_1  vss  200f
R_bleed_3_1  vw_route_3_1  vss  10000meg
XMN4_r_3_1  vw_route_3_1  we_route  iwrite_route_3_1  vss  sky130_fd_pr__nfet_01v8  w=0.5  l=0.5
X_rhebb_3_1  iwrite_route_3_1  inp_upper_1  ierr_dig_3  vcm_route  vdd vss  hebbian_mult
XMPRED_r_3_2  i_pred_3  vw_route_3_2  vss  vss  sky130_fd_pr__nfet_01v8  w=4  l=0.35
Cw_route_3_2  vw_route_3_2  vss  200f
R_bleed_3_2  vw_route_3_2  vss  10000meg
XMN4_r_3_2  vw_route_3_2  we_route  iwrite_route_3_2  vss  sky130_fd_pr__nfet_01v8  w=0.5  l=0.5
X_rhebb_3_2  iwrite_route_3_2  inp_upper_2  ierr_dig_3  vcm_route  vdd vss  hebbian_mult
XMPRED_r_3_3  i_pred_3  vw_route_3_3  vss  vss  sky130_fd_pr__nfet_01v8  w=4  l=0.35
Cw_route_3_3  vw_route_3_3  vss  200f
R_bleed_3_3  vw_route_3_3  vss  10000meg
XMN4_r_3_3  vw_route_3_3  we_route  iwrite_route_3_3  vss  sky130_fd_pr__nfet_01v8  w=0.5  l=0.5
X_rhebb_3_3  iwrite_route_3_3  inp_upper_3  ierr_dig_3  vcm_route  vdd vss  hebbian_mult

.ends layer_link_route_4
