* =============================================================================
* PCN Module — 8-Bit R-2R Weight DAC
* File:      weight_dac.spice
* Simulator: ngspice 42+
*
* Converts an 8-bit digital weight word D[7:0] into an analog voltage Vdac
* in the range 0 V (D=0) to Vref (D=255), using an R-2R resistor ladder.
*
*   Vdac = Vref × D / 256
*
* Transfer function over the useful weight range (Vw ≈ 0.5–1.3 V):
*   LSB = Vref / 256 = 1.8 / 256 ≈ 7 mV
*   Usable codes: ~57 (Vw=0.5V) to ~185 (Vw=1.3V) = 114 codes ≈ 6.8 effective bits
*
* Architecture:
*   - 7 series R (50 kΩ) connecting ladder nodes n7..n0
*   - 8 shunt 2R (100 kΩ) at each ladder node to bit switch
*   - 1 termination 2R (100 kΩ) from n0 to VSS
*   - Each bit switch selects the shunt 2R connection to Vref (b=1) or VSS (b=0)
*
* Switch implementation:
*   Ideal voltage-controlled switches (SW model, Ron=100Ω) with B-source
*   inverters to generate complementary controls.  Transistor-level CMOS TG
*   sizes for layout (not instantiated here):
*     MN_sw: W=0.5µm / L=0.35µm  (sky130_fd_pr__nfet_01v8)
*     MP_sw: W=1.0µm / L=0.35µm  (sky130_fd_pr__pfet_01v8)
*
* Settling time to target cell (Cw = 200 fF through R = 50 kΩ):
*   τ = 50 kΩ × 200 fF = 10 ns;  5τ = 50 ns — one weight load per 80 ns slot.
*
* Static power (all bits = 1, worst case):
*   Ivref = Vref / R = 1.8 V / 50 kΩ = 36 µA — tolerable during weight loads.
*
* Reference: pred_code_networks.md §21 (Parts A–D)
*
* Port map:  vdd vss vref b7 b6 b5 b4 b3 b2 b1 b0 vdac
*            b7 = MSB (weight of 128), b0 = LSB (weight of 1)
*            Bits are digital signals: 0 V (bit=0) or Vdd (bit=1)
* =============================================================================

.subckt weight_dac vdd vss vref b7 b6 b5 b4 b3 b2 b1 b0 vdac

* =============================================================================
* SWITCH MODEL
* =============================================================================
* Single-polarity switch: ON when control > 1.3 V (Vt+Vh), OFF below 0.5 V.
* Ron = 100 Ω << R_ladder (50 kΩ) → negligible DNL error.
* Roff = 1 GΩ >> R_ladder           → negligible leakage.

.model sw_hi sw (Ron=100 Roff=1G Vt=0.9 Vh=0.4)

* =============================================================================
* COMPLEMENTARY BIT SIGNALS (B-source inverters, no PDK required)
* =============================================================================
* nb_k = logical NOT of b_k: 0V when b_k=Vdd, Vdd when b_k=0V.
* Arithmetic formulation (avoids {?:} ternary — incompatible with ngspice
* Hspice compatibility mode triggered by sky130 option SCALE=1e-6):
*   nb = vdd - b   (exact for digital signals that are always 0V or VDD)

Binv7 nb7 0 V = v(vdd) - v(b7)
Binv6 nb6 0 V = v(vdd) - v(b6)
Binv5 nb5 0 V = v(vdd) - v(b5)
Binv4 nb4 0 V = v(vdd) - v(b4)
Binv3 nb3 0 V = v(vdd) - v(b3)
Binv2 nb2 0 V = v(vdd) - v(b2)
Binv1 nb1 0 V = v(vdd) - v(b1)
Binv0 nb0 0 V = v(vdd) - v(b0)

* =============================================================================
* R-2R LADDER NETWORK
* =============================================================================
*
*   vdac (= n7)
*    │
*    n7─[R50k]─n6─[R50k]─n5─[R50k]─n4─[R50k]─n3─[R50k]─n2─[R50k]─n1─[R50k]─n0─[2R100k]─VSS
*    │          │          │          │          │          │          │          │
*  [2R]       [2R]       [2R]       [2R]       [2R]       [2R]       [2R]       [2R]
*    │          │          │          │          │          │          │          │
*   nt7        nt6        nt5        nt4        nt3        nt2        nt1        nt0
*    │          │          │          │          │          │          │          │
*  sw→Vref    sw→Vref    sw→Vref    sw→Vref    sw→Vref    sw→Vref    sw→Vref    sw→Vref
*  sw→VSS     sw→VSS     sw→VSS     sw→VSS     sw→VSS     sw→VSS     sw→VSS     sw→VSS
*  (b7/nb7)   (b6/nb6)   ...

* Series R elements (50 kΩ each)
Rs7 vdac n6  50000
Rs6  n6  n5  50000
Rs5  n5  n4  50000
Rs4  n4  n3  50000
Rs3  n3  n2  50000
Rs2  n2  n1  50000
Rs1  n1  n0  50000

* Termination 2R at LSB end (always to VSS, no switch)
Rterm n0 vss 100000

* Shunt 2R from each ladder node to the bit switch tap
Rsh7 vdac nt7 100000
Rsh6  n6  nt6 100000
Rsh5  n5  nt5 100000
Rsh4  n4  nt4 100000
Rsh3  n3  nt3 100000
Rsh2  n2  nt2 100000
Rsh1  n1  nt1 100000
Rsh0  n0  nt0 100000

* =============================================================================
* BIT SWITCHES — connect each 2R shunt tap to Vref (b=1) or VSS (b=0)
* =============================================================================
* Each node uses two complementary sw_hi switches.
* Sref_k: closed when b_k=HIGH (b_k > 1.3V) → nt_k = Vref
* Sgnd_k: closed when b_k=LOW  (nb_k > 1.3V) → nt_k = VSS
* Exactly one of each pair is closed at any time (mutual exclusion).

Sref7 nt7 vref  b7 0 sw_hi
Sgnd7 nt7 vss  nb7 0 sw_hi

Sref6 nt6 vref  b6 0 sw_hi
Sgnd6 nt6 vss  nb6 0 sw_hi

Sref5 nt5 vref  b5 0 sw_hi
Sgnd5 nt5 vss  nb5 0 sw_hi

Sref4 nt4 vref  b4 0 sw_hi
Sgnd4 nt4 vss  nb4 0 sw_hi

Sref3 nt3 vref  b3 0 sw_hi
Sgnd3 nt3 vss  nb3 0 sw_hi

Sref2 nt2 vref  b2 0 sw_hi
Sgnd2 nt2 vss  nb2 0 sw_hi

Sref1 nt1 vref  b1 0 sw_hi
Sgnd1 nt1 vss  nb1 0 sw_hi

Sref0 nt0 vref  b0 0 sw_hi
Sgnd0 nt0 vss  nb0 0 sw_hi

* =============================================================================
* NOTES FOR LAYOUT
* =============================================================================
*
* Replace ideal SW with CMOS TG (per design doc §21B):
*   MN_sw: W=0.5µm / L=0.35µm  (sky130_fd_pr__nfet_01v8)
*   MP_sw: W=1.0µm / L=0.35µm  (sky130_fd_pr__pfet_01v8)
*
* Replace B-source inverters with sky130_fd_sc_hd__inv_1 standard cells
* (or minimum-size custom inverters: XINk nout vin vdd vdd pfet_01v8 w=1 l=0.15
*                                    XINk nout vin vss vss nfet_01v8 w=0.5 l=0.15)
*
* Resistor sizing (sky130_fd_pr__res_high_po_0p35, ~2 kΩ/sq, W=0.35µm):
*   R  = 50 kΩ  → 25 squares → length = 8.75 µm
*   2R = 100 kΩ → 50 squares → length = 17.5 µm
*
* Common-centroid layout for Rs7..Rs1 to cancel linear gradient.
* 2R shunts Rsh7..Rsh0 and Rterm: match as 2× R_unit in series.
*
* Decoupling: 100 fF MOSCAP at Vref entry and Vdac output.

.ends weight_dac
