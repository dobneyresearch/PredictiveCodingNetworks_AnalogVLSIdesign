* =============================================================================
* tb_pcn_4layer.spice — 4-module 16×16 chip integration testbench
* Generated by gen_tb_4layer.py  — DO NOT EDIT by hand.
*
* Tests:
*   T1 (op-point):  bias rails correct; ascending path m0→m1→m2→m3 verified;
*                   descending predictions m0_pred..m2_pred non-zero; error
*                   flags HIGH at top (mod3, i_pred=VSS) and variable below.
*   T2 (DC sweep):  raw_inp_0 ±50mV; signal gain tracked layer by layer.
*   T3 (transient): Hebbian write on mod0 row 0; ΔVw > 0 confirms LTP path.
*
* Circuit hierarchy:
*   Stiff sources — vbias_n=0.760V, vcm=0.900V, vpi=0.650V, ncm_iout=0.468V
*   ncm_iout = actual balanced iout OP (NOT Vcm=0.9V which is the input CM) (§72 fix)
*   PMOS SF level shift (§71/72): V(m0_iout)≈0.468V + |Vgs_P|≈0.67V → V(m1_inp)≈1.14V
*   vcm_upper per link: ref PMOS SF output ≈ ncm_iout + |Vgs_P| ≈ 1.14V (§72 fix)
*   vcm_upper_01/12/23 are driven by the reference SFs inside each layer_link_16.
*   Xmod0..Xmod3     — pcn_module_16x16 (array + current_sub + precision_gate)
*   Xlink_01..23     — layer_link_16 (ascending PMOS SF + descending XMPRED)
* =============================================================================

.title PCN 4-Layer 16×16 Chip Integration Testbench

.lib "$PDK_ROOT/sky130A/libs.tech/ngspice/sky130.lib.spice" tt
.include "pcn_mac_cell.spice"
.include "pcn_array_16x16.spice"
.include "pcn_module_16x16.spice"
.include "layer_link.spice"

* ── Simulation options ───────────────────────────────────────────────────────
.options RELTOL=1e-3 ABSTOL=1e-12 VNTOL=1e-6 GMIN=1e-10 ITL1=300 ITL4=100

* ── Supplies ─────────────────────────────────────────────────────────────────
Vvdd  vdd  0  DC 1.8
Vvss  vss  0  DC 0

* ── Stiff bias rails ─────────────────────────────────────────────────────────
* vcm_upper_01/12/23: driven by reference SFs inside each layer_link_16 (§71).
* ncm_iout: stiff 0.468V — actual balanced iout OP (measured); drives reference SF
*           gate so vcm_upper tracks actual iout CM, not input Vcm (§72 fix).
Vbias_n    vbias_n    0  DC 0.760
Vcm_src    vcm        0  DC 0.900
Vpi_src    vpi        0  DC 0.650
Vcm_iout   ncm_iout   0  DC 0.468

* ── nc_vbias_p: floating port in all modules — tie weakly to VDD ───────────
Rnc  nc_vbias_p  vdd  1000meg

* ── Module 0 column inputs ───────────────────────────────────────────────────
Vinp0  raw_inp_0  0  DC 0.9
Vinp1  raw_inp_1  0  DC 0.9
Vinp2  raw_inp_2  0  DC 0.9
Vinp3  raw_inp_3  0  DC 0.9
Vinp4  raw_inp_4  0  DC 0.9
Vinp5  raw_inp_5  0  DC 0.9
Vinp6  raw_inp_6  0  DC 0.9
Vinp7  raw_inp_7  0  DC 0.9
Vinp8  raw_inp_8  0  DC 0.9
Vinp9  raw_inp_9  0  DC 0.9
Vinp10  raw_inp_10  0  DC 0.9
Vinp11  raw_inp_11  0  DC 0.9
Vinp12  raw_inp_12  0  DC 0.9
Vinp13  raw_inp_13  0  DC 0.9
Vinp14  raw_inp_14  0  DC 0.9
Vinp15  raw_inp_15  0  DC 0.9

* ── Write-enable sources (all LOW; we_m0_0 gets pulse in T3) ─────────────────
Vwe_m0_0  we_m0_0  0  PULSE(0 1.8 50n 1n 1n 20n 200n)
Vwe_m0_1  we_m0_1  0  DC 0
Vwe_m0_2  we_m0_2  0  DC 0
Vwe_m0_3  we_m0_3  0  DC 0
Vwe_m0_4  we_m0_4  0  DC 0
Vwe_m0_5  we_m0_5  0  DC 0
Vwe_m0_6  we_m0_6  0  DC 0
Vwe_m0_7  we_m0_7  0  DC 0
Vwe_m0_8  we_m0_8  0  DC 0
Vwe_m0_9  we_m0_9  0  DC 0
Vwe_m0_10  we_m0_10  0  DC 0
Vwe_m0_11  we_m0_11  0  DC 0
Vwe_m0_12  we_m0_12  0  DC 0
Vwe_m0_13  we_m0_13  0  DC 0
Vwe_m0_14  we_m0_14  0  DC 0
Vwe_m0_15  we_m0_15  0  DC 0
Vwe_m1_0  we_m1_0  0  DC 0
Vwe_m1_1  we_m1_1  0  DC 0
Vwe_m1_2  we_m1_2  0  DC 0
Vwe_m1_3  we_m1_3  0  DC 0
Vwe_m1_4  we_m1_4  0  DC 0
Vwe_m1_5  we_m1_5  0  DC 0
Vwe_m1_6  we_m1_6  0  DC 0
Vwe_m1_7  we_m1_7  0  DC 0
Vwe_m1_8  we_m1_8  0  DC 0
Vwe_m1_9  we_m1_9  0  DC 0
Vwe_m1_10  we_m1_10  0  DC 0
Vwe_m1_11  we_m1_11  0  DC 0
Vwe_m1_12  we_m1_12  0  DC 0
Vwe_m1_13  we_m1_13  0  DC 0
Vwe_m1_14  we_m1_14  0  DC 0
Vwe_m1_15  we_m1_15  0  DC 0
Vwe_m2_0  we_m2_0  0  DC 0
Vwe_m2_1  we_m2_1  0  DC 0
Vwe_m2_2  we_m2_2  0  DC 0
Vwe_m2_3  we_m2_3  0  DC 0
Vwe_m2_4  we_m2_4  0  DC 0
Vwe_m2_5  we_m2_5  0  DC 0
Vwe_m2_6  we_m2_6  0  DC 0
Vwe_m2_7  we_m2_7  0  DC 0
Vwe_m2_8  we_m2_8  0  DC 0
Vwe_m2_9  we_m2_9  0  DC 0
Vwe_m2_10  we_m2_10  0  DC 0
Vwe_m2_11  we_m2_11  0  DC 0
Vwe_m2_12  we_m2_12  0  DC 0
Vwe_m2_13  we_m2_13  0  DC 0
Vwe_m2_14  we_m2_14  0  DC 0
Vwe_m2_15  we_m2_15  0  DC 0
Vwe_m3_0  we_m3_0  0  DC 0
Vwe_m3_1  we_m3_1  0  DC 0
Vwe_m3_2  we_m3_2  0  DC 0
Vwe_m3_3  we_m3_3  0  DC 0
Vwe_m3_4  we_m3_4  0  DC 0
Vwe_m3_5  we_m3_5  0  DC 0
Vwe_m3_6  we_m3_6  0  DC 0
Vwe_m3_7  we_m3_7  0  DC 0
Vwe_m3_8  we_m3_8  0  DC 0
Vwe_m3_9  we_m3_9  0  DC 0
Vwe_m3_10  we_m3_10  0  DC 0
Vwe_m3_11  we_m3_11  0  DC 0
Vwe_m3_12  we_m3_12  0  DC 0
Vwe_m3_13  we_m3_13  0  DC 0
Vwe_m3_14  we_m3_14  0  DC 0
Vwe_m3_15  we_m3_15  0  DC 0

* =============================================================================
* Module 0 — bottom layer: raw input at vcm=0.9V
* =============================================================================
Xmod0
+ raw_inp_0  vcm raw_inp_1  vcm raw_inp_2  vcm raw_inp_3  vcm raw_inp_4  vcm raw_inp_5  vcm raw_inp_6  vcm raw_inp_7  vcm raw_inp_8  vcm raw_inp_9  vcm raw_inp_10  vcm raw_inp_11  vcm raw_inp_12  vcm raw_inp_13  vcm raw_inp_14  vcm raw_inp_15  vcm
+ m0_iout_0 m0_iout_1 m0_iout_2 m0_iout_3 m0_iout_4 m0_iout_5 m0_iout_6 m0_iout_7 m0_iout_8 m0_iout_9 m0_iout_10 m0_iout_11 m0_iout_12 m0_iout_13 m0_iout_14 m0_iout_15
+ m0_pred_0 m0_pred_1 m0_pred_2 m0_pred_3 m0_pred_4 m0_pred_5 m0_pred_6 m0_pred_7 m0_pred_8 m0_pred_9 m0_pred_10 m0_pred_11 m0_pred_12 m0_pred_13 m0_pred_14 m0_pred_15
+ ierr_m0_0 ierr_m0_1 ierr_m0_2 ierr_m0_3 ierr_m0_4 ierr_m0_5 ierr_m0_6 ierr_m0_7 ierr_m0_8 ierr_m0_9 ierr_m0_10 ierr_m0_11 ierr_m0_12 ierr_m0_13 ierr_m0_14 ierr_m0_15
+ we_m0_0 we_m0_1 we_m0_2 we_m0_3 we_m0_4 we_m0_5 we_m0_6 we_m0_7 we_m0_8 we_m0_9 we_m0_10 we_m0_11 we_m0_12 we_m0_13 we_m0_14 we_m0_15
+ vpi vpi vpi vpi vpi vpi vpi vpi vpi vpi vpi vpi vpi vpi vpi vpi
+ nc_vbias_p  vbias_n  vcm  vdd  vss
+ pcn_module_16x16

* =============================================================================
* Layer link 0 → 1
* vcm_upper_01: ref-SF output ≈ ncm_iout + |Vgs_P| ≈ 1.14V (§72 fix)
* =============================================================================
Xlink_01
+ m0_iout_0 m0_iout_1 m0_iout_2 m0_iout_3 m0_iout_4 m0_iout_5 m0_iout_6 m0_iout_7 m0_iout_8 m0_iout_9 m0_iout_10 m0_iout_11 m0_iout_12 m0_iout_13 m0_iout_14 m0_iout_15
+ m1_inp_0 m1_inp_1 m1_inp_2 m1_inp_3 m1_inp_4 m1_inp_5 m1_inp_6 m1_inp_7 m1_inp_8 m1_inp_9 m1_inp_10 m1_inp_11 m1_inp_12 m1_inp_13 m1_inp_14 m1_inp_15
+ m0_pred_0 m0_pred_1 m0_pred_2 m0_pred_3 m0_pred_4 m0_pred_5 m0_pred_6 m0_pred_7 m0_pred_8 m0_pred_9 m0_pred_10 m0_pred_11 m0_pred_12 m0_pred_13 m0_pred_14 m0_pred_15
+ m1_iout_0 m1_iout_1 m1_iout_2 m1_iout_3 m1_iout_4 m1_iout_5 m1_iout_6 m1_iout_7 m1_iout_8 m1_iout_9 m1_iout_10 m1_iout_11 m1_iout_12 m1_iout_13 m1_iout_14 m1_iout_15
+ vcm_upper_01 ncm_iout vbias_n vdd vss
+ layer_link_16

* =============================================================================
* Module 1 — layer 1: m1_inp from PMOS SF (≈1.53V); inn_col = vcm_upper_01 (≈1.55V)
* =============================================================================
Xmod1
+ m1_inp_0  vcm_upper_01 m1_inp_1  vcm_upper_01 m1_inp_2  vcm_upper_01 m1_inp_3  vcm_upper_01 m1_inp_4  vcm_upper_01 m1_inp_5  vcm_upper_01 m1_inp_6  vcm_upper_01 m1_inp_7  vcm_upper_01 m1_inp_8  vcm_upper_01 m1_inp_9  vcm_upper_01 m1_inp_10  vcm_upper_01 m1_inp_11  vcm_upper_01 m1_inp_12  vcm_upper_01 m1_inp_13  vcm_upper_01 m1_inp_14  vcm_upper_01 m1_inp_15  vcm_upper_01
+ m1_iout_0 m1_iout_1 m1_iout_2 m1_iout_3 m1_iout_4 m1_iout_5 m1_iout_6 m1_iout_7 m1_iout_8 m1_iout_9 m1_iout_10 m1_iout_11 m1_iout_12 m1_iout_13 m1_iout_14 m1_iout_15
+ m1_pred_0 m1_pred_1 m1_pred_2 m1_pred_3 m1_pred_4 m1_pred_5 m1_pred_6 m1_pred_7 m1_pred_8 m1_pred_9 m1_pred_10 m1_pred_11 m1_pred_12 m1_pred_13 m1_pred_14 m1_pred_15
+ ierr_m1_0 ierr_m1_1 ierr_m1_2 ierr_m1_3 ierr_m1_4 ierr_m1_5 ierr_m1_6 ierr_m1_7 ierr_m1_8 ierr_m1_9 ierr_m1_10 ierr_m1_11 ierr_m1_12 ierr_m1_13 ierr_m1_14 ierr_m1_15
+ we_m1_0 we_m1_1 we_m1_2 we_m1_3 we_m1_4 we_m1_5 we_m1_6 we_m1_7 we_m1_8 we_m1_9 we_m1_10 we_m1_11 we_m1_12 we_m1_13 we_m1_14 we_m1_15
+ vpi vpi vpi vpi vpi vpi vpi vpi vpi vpi vpi vpi vpi vpi vpi vpi
+ nc_vbias_p  vbias_n  vcm_upper_01  vdd  vss
+ pcn_module_16x16

* =============================================================================
* Layer link 1 → 2
* vcm_upper_12: driven by Xlink_12 reference PMOS SF (§72 fix)
* =============================================================================
Xlink_12
+ m1_iout_0 m1_iout_1 m1_iout_2 m1_iout_3 m1_iout_4 m1_iout_5 m1_iout_6 m1_iout_7 m1_iout_8 m1_iout_9 m1_iout_10 m1_iout_11 m1_iout_12 m1_iout_13 m1_iout_14 m1_iout_15
+ m2_inp_0 m2_inp_1 m2_inp_2 m2_inp_3 m2_inp_4 m2_inp_5 m2_inp_6 m2_inp_7 m2_inp_8 m2_inp_9 m2_inp_10 m2_inp_11 m2_inp_12 m2_inp_13 m2_inp_14 m2_inp_15
+ m1_pred_0 m1_pred_1 m1_pred_2 m1_pred_3 m1_pred_4 m1_pred_5 m1_pred_6 m1_pred_7 m1_pred_8 m1_pred_9 m1_pred_10 m1_pred_11 m1_pred_12 m1_pred_13 m1_pred_14 m1_pred_15
+ m2_iout_0 m2_iout_1 m2_iout_2 m2_iout_3 m2_iout_4 m2_iout_5 m2_iout_6 m2_iout_7 m2_iout_8 m2_iout_9 m2_iout_10 m2_iout_11 m2_iout_12 m2_iout_13 m2_iout_14 m2_iout_15
+ vcm_upper_12 ncm_iout vbias_n vdd vss
+ layer_link_16

* =============================================================================
* Module 2 — layer 2: inn_col = vcm_upper_12
* =============================================================================
Xmod2
+ m2_inp_0  vcm_upper_12 m2_inp_1  vcm_upper_12 m2_inp_2  vcm_upper_12 m2_inp_3  vcm_upper_12 m2_inp_4  vcm_upper_12 m2_inp_5  vcm_upper_12 m2_inp_6  vcm_upper_12 m2_inp_7  vcm_upper_12 m2_inp_8  vcm_upper_12 m2_inp_9  vcm_upper_12 m2_inp_10  vcm_upper_12 m2_inp_11  vcm_upper_12 m2_inp_12  vcm_upper_12 m2_inp_13  vcm_upper_12 m2_inp_14  vcm_upper_12 m2_inp_15  vcm_upper_12
+ m2_iout_0 m2_iout_1 m2_iout_2 m2_iout_3 m2_iout_4 m2_iout_5 m2_iout_6 m2_iout_7 m2_iout_8 m2_iout_9 m2_iout_10 m2_iout_11 m2_iout_12 m2_iout_13 m2_iout_14 m2_iout_15
+ m2_pred_0 m2_pred_1 m2_pred_2 m2_pred_3 m2_pred_4 m2_pred_5 m2_pred_6 m2_pred_7 m2_pred_8 m2_pred_9 m2_pred_10 m2_pred_11 m2_pred_12 m2_pred_13 m2_pred_14 m2_pred_15
+ ierr_m2_0 ierr_m2_1 ierr_m2_2 ierr_m2_3 ierr_m2_4 ierr_m2_5 ierr_m2_6 ierr_m2_7 ierr_m2_8 ierr_m2_9 ierr_m2_10 ierr_m2_11 ierr_m2_12 ierr_m2_13 ierr_m2_14 ierr_m2_15
+ we_m2_0 we_m2_1 we_m2_2 we_m2_3 we_m2_4 we_m2_5 we_m2_6 we_m2_7 we_m2_8 we_m2_9 we_m2_10 we_m2_11 we_m2_12 we_m2_13 we_m2_14 we_m2_15
+ vpi vpi vpi vpi vpi vpi vpi vpi vpi vpi vpi vpi vpi vpi vpi vpi
+ nc_vbias_p  vbias_n  vcm_upper_12  vdd  vss
+ pcn_module_16x16

* =============================================================================
* Layer link 2 → 3
* vcm_upper_23: driven by Xlink_23 reference PMOS SF (§72 fix)
* =============================================================================
Xlink_23
+ m2_iout_0 m2_iout_1 m2_iout_2 m2_iout_3 m2_iout_4 m2_iout_5 m2_iout_6 m2_iout_7 m2_iout_8 m2_iout_9 m2_iout_10 m2_iout_11 m2_iout_12 m2_iout_13 m2_iout_14 m2_iout_15
+ m3_inp_0 m3_inp_1 m3_inp_2 m3_inp_3 m3_inp_4 m3_inp_5 m3_inp_6 m3_inp_7 m3_inp_8 m3_inp_9 m3_inp_10 m3_inp_11 m3_inp_12 m3_inp_13 m3_inp_14 m3_inp_15
+ m2_pred_0 m2_pred_1 m2_pred_2 m2_pred_3 m2_pred_4 m2_pred_5 m2_pred_6 m2_pred_7 m2_pred_8 m2_pred_9 m2_pred_10 m2_pred_11 m2_pred_12 m2_pred_13 m2_pred_14 m2_pred_15
+ m3_iout_0 m3_iout_1 m3_iout_2 m3_iout_3 m3_iout_4 m3_iout_5 m3_iout_6 m3_iout_7 m3_iout_8 m3_iout_9 m3_iout_10 m3_iout_11 m3_iout_12 m3_iout_13 m3_iout_14 m3_iout_15
+ vcm_upper_23 ncm_iout vbias_n vdd vss
+ layer_link_16

* =============================================================================
* Module 3 — top layer: i_pred=VSS (unsupervised); inn_col = vcm_upper_23
* =============================================================================
Xmod3
+ m3_inp_0  vcm_upper_23 m3_inp_1  vcm_upper_23 m3_inp_2  vcm_upper_23 m3_inp_3  vcm_upper_23 m3_inp_4  vcm_upper_23 m3_inp_5  vcm_upper_23 m3_inp_6  vcm_upper_23 m3_inp_7  vcm_upper_23 m3_inp_8  vcm_upper_23 m3_inp_9  vcm_upper_23 m3_inp_10  vcm_upper_23 m3_inp_11  vcm_upper_23 m3_inp_12  vcm_upper_23 m3_inp_13  vcm_upper_23 m3_inp_14  vcm_upper_23 m3_inp_15  vcm_upper_23
+ m3_iout_0 m3_iout_1 m3_iout_2 m3_iout_3 m3_iout_4 m3_iout_5 m3_iout_6 m3_iout_7 m3_iout_8 m3_iout_9 m3_iout_10 m3_iout_11 m3_iout_12 m3_iout_13 m3_iout_14 m3_iout_15
+ vss vss vss vss vss vss vss vss vss vss vss vss vss vss vss vss
+ ierr_m3_0 ierr_m3_1 ierr_m3_2 ierr_m3_3 ierr_m3_4 ierr_m3_5 ierr_m3_6 ierr_m3_7 ierr_m3_8 ierr_m3_9 ierr_m3_10 ierr_m3_11 ierr_m3_12 ierr_m3_13 ierr_m3_14 ierr_m3_15
+ we_m3_0 we_m3_1 we_m3_2 we_m3_3 we_m3_4 we_m3_5 we_m3_6 we_m3_7 we_m3_8 we_m3_9 we_m3_10 we_m3_11 we_m3_12 we_m3_13 we_m3_14 we_m3_15
+ vpi vpi vpi vpi vpi vpi vpi vpi vpi vpi vpi vpi vpi vpi vpi vpi
+ nc_vbias_p  vbias_n  vcm_upper_23  vdd  vss
+ pcn_module_16x16

* =============================================================================
* Nodesets — convergence seeds
* =============================================================================

* Bias rails
.nodeset V(vbias_n)=0.760  V(vcm)=0.900  V(vpi)=0.650

* vcm_upper per link: reference PMOS SF output ≈ ncm_iout + |Vgs_P| ≈ 1.14V (§72 fix)
.nodeset V(vcm_upper_01)=1.14  V(vcm_upper_12)=1.14  V(vcm_upper_23)=1.14
.nodeset V(ncm_iout)=0.468

.nodeset V(nc_vbias_p)=1.8

* KCL bus nodes: all modules, all rows
.nodeset V(m0_iout_0)=0.468  V(m0_iout_1)=0.468  V(m0_iout_2)=0.468  V(m0_iout_3)=0.468  V(m0_iout_4)=0.468  V(m0_iout_5)=0.468  V(m0_iout_6)=0.468  V(m0_iout_7)=0.468  V(m0_iout_8)=0.468  V(m0_iout_9)=0.468  V(m0_iout_10)=0.468  V(m0_iout_11)=0.468  V(m0_iout_12)=0.468  V(m0_iout_13)=0.468  V(m0_iout_14)=0.468  V(m0_iout_15)=0.468
.nodeset V(m1_iout_0)=0.468  V(m1_iout_1)=0.468  V(m1_iout_2)=0.468  V(m1_iout_3)=0.468  V(m1_iout_4)=0.468  V(m1_iout_5)=0.468  V(m1_iout_6)=0.468  V(m1_iout_7)=0.468  V(m1_iout_8)=0.468  V(m1_iout_9)=0.468  V(m1_iout_10)=0.468  V(m1_iout_11)=0.468  V(m1_iout_12)=0.468  V(m1_iout_13)=0.468  V(m1_iout_14)=0.468  V(m1_iout_15)=0.468
.nodeset V(m2_iout_0)=0.468  V(m2_iout_1)=0.468  V(m2_iout_2)=0.468  V(m2_iout_3)=0.468  V(m2_iout_4)=0.468  V(m2_iout_5)=0.468  V(m2_iout_6)=0.468  V(m2_iout_7)=0.468  V(m2_iout_8)=0.468  V(m2_iout_9)=0.468  V(m2_iout_10)=0.468  V(m2_iout_11)=0.468  V(m2_iout_12)=0.468  V(m2_iout_13)=0.468  V(m2_iout_14)=0.468  V(m2_iout_15)=0.468
.nodeset V(m3_iout_0)=0.468  V(m3_iout_1)=0.468  V(m3_iout_2)=0.468  V(m3_iout_3)=0.468  V(m3_iout_4)=0.468  V(m3_iout_5)=0.468  V(m3_iout_6)=0.468  V(m3_iout_7)=0.468  V(m3_iout_8)=0.468  V(m3_iout_9)=0.468  V(m3_iout_10)=0.468  V(m3_iout_11)=0.468  V(m3_iout_12)=0.468  V(m3_iout_13)=0.468  V(m3_iout_14)=0.468  V(m3_iout_15)=0.468

* Layer-link ascending outputs (PMOS SF — raises voltage)
.nodeset V(m1_inp_0)=1.14  V(m1_inp_1)=1.14  V(m1_inp_2)=1.14  V(m1_inp_3)=1.14  V(m1_inp_4)=1.14  V(m1_inp_5)=1.14  V(m1_inp_6)=1.14  V(m1_inp_7)=1.14  V(m1_inp_8)=1.14  V(m1_inp_9)=1.14  V(m1_inp_10)=1.14  V(m1_inp_11)=1.14  V(m1_inp_12)=1.14  V(m1_inp_13)=1.14  V(m1_inp_14)=1.14  V(m1_inp_15)=1.14
.nodeset V(m2_inp_0)=1.14  V(m2_inp_1)=1.14  V(m2_inp_2)=1.14  V(m2_inp_3)=1.14  V(m2_inp_4)=1.14  V(m2_inp_5)=1.14  V(m2_inp_6)=1.14  V(m2_inp_7)=1.14  V(m2_inp_8)=1.14  V(m2_inp_9)=1.14  V(m2_inp_10)=1.14  V(m2_inp_11)=1.14  V(m2_inp_12)=1.14  V(m2_inp_13)=1.14  V(m2_inp_14)=1.14  V(m2_inp_15)=1.14
.nodeset V(m3_inp_0)=1.14  V(m3_inp_1)=1.14  V(m3_inp_2)=1.14  V(m3_inp_3)=1.14  V(m3_inp_4)=1.14  V(m3_inp_5)=1.14  V(m3_inp_6)=1.14  V(m3_inp_7)=1.14  V(m3_inp_8)=1.14  V(m3_inp_9)=1.14  V(m3_inp_10)=1.14  V(m3_inp_11)=1.14  V(m3_inp_12)=1.14  V(m3_inp_13)=1.14  V(m3_inp_14)=1.14  V(m3_inp_15)=1.14

* Descending prediction nodes
.nodeset V(m0_pred_0)=0.01  V(m0_pred_1)=0.01  V(m0_pred_2)=0.01  V(m0_pred_3)=0.01  V(m0_pred_4)=0.01  V(m0_pred_5)=0.01  V(m0_pred_6)=0.01  V(m0_pred_7)=0.01  V(m0_pred_8)=0.01  V(m0_pred_9)=0.01  V(m0_pred_10)=0.01  V(m0_pred_11)=0.01  V(m0_pred_12)=0.01  V(m0_pred_13)=0.01  V(m0_pred_14)=0.01  V(m0_pred_15)=0.01
.nodeset V(m1_pred_0)=0.01  V(m1_pred_1)=0.01  V(m1_pred_2)=0.01  V(m1_pred_3)=0.01  V(m1_pred_4)=0.01  V(m1_pred_5)=0.01  V(m1_pred_6)=0.01  V(m1_pred_7)=0.01  V(m1_pred_8)=0.01  V(m1_pred_9)=0.01  V(m1_pred_10)=0.01  V(m1_pred_11)=0.01  V(m1_pred_12)=0.01  V(m1_pred_13)=0.01  V(m1_pred_14)=0.01  V(m1_pred_15)=0.01
.nodeset V(m2_pred_0)=0.01  V(m2_pred_1)=0.01  V(m2_pred_2)=0.01  V(m2_pred_3)=0.01  V(m2_pred_4)=0.01  V(m2_pred_5)=0.01  V(m2_pred_6)=0.01  V(m2_pred_7)=0.01  V(m2_pred_8)=0.01  V(m2_pred_9)=0.01  V(m2_pred_10)=0.01  V(m2_pred_11)=0.01  V(m2_pred_12)=0.01  V(m2_pred_13)=0.01  V(m2_pred_14)=0.01  V(m2_pred_15)=0.01

* ierr_dig (digital error outputs): seed HIGH
.nodeset V(ierr_m0_0)=1.8  V(ierr_m0_1)=1.8  V(ierr_m0_2)=1.8  V(ierr_m0_3)=1.8  V(ierr_m0_4)=1.8  V(ierr_m0_5)=1.8  V(ierr_m0_6)=1.8  V(ierr_m0_7)=1.8  V(ierr_m0_8)=1.8  V(ierr_m0_9)=1.8  V(ierr_m0_10)=1.8  V(ierr_m0_11)=1.8  V(ierr_m0_12)=1.8  V(ierr_m0_13)=1.8  V(ierr_m0_14)=1.8  V(ierr_m0_15)=1.8
.nodeset V(ierr_m1_0)=1.8  V(ierr_m1_1)=1.8  V(ierr_m1_2)=1.8  V(ierr_m1_3)=1.8  V(ierr_m1_4)=1.8  V(ierr_m1_5)=1.8  V(ierr_m1_6)=1.8  V(ierr_m1_7)=1.8  V(ierr_m1_8)=1.8  V(ierr_m1_9)=1.8  V(ierr_m1_10)=1.8  V(ierr_m1_11)=1.8  V(ierr_m1_12)=1.8  V(ierr_m1_13)=1.8  V(ierr_m1_14)=1.8  V(ierr_m1_15)=1.8
.nodeset V(ierr_m2_0)=1.8  V(ierr_m2_1)=1.8  V(ierr_m2_2)=1.8  V(ierr_m2_3)=1.8  V(ierr_m2_4)=1.8  V(ierr_m2_5)=1.8  V(ierr_m2_6)=1.8  V(ierr_m2_7)=1.8  V(ierr_m2_8)=1.8  V(ierr_m2_9)=1.8  V(ierr_m2_10)=1.8  V(ierr_m2_11)=1.8  V(ierr_m2_12)=1.8  V(ierr_m2_13)=1.8  V(ierr_m2_14)=1.8  V(ierr_m2_15)=1.8
.nodeset V(ierr_m3_0)=1.8  V(ierr_m3_1)=1.8  V(ierr_m3_2)=1.8  V(ierr_m3_3)=1.8  V(ierr_m3_4)=1.8  V(ierr_m3_5)=1.8  V(ierr_m3_6)=1.8  V(ierr_m3_7)=1.8  V(ierr_m3_8)=1.8  V(ierr_m3_9)=1.8  V(ierr_m3_10)=1.8  V(ierr_m3_11)=1.8  V(ierr_m3_12)=1.8  V(ierr_m3_13)=1.8  V(ierr_m3_14)=1.8  V(ierr_m3_15)=1.8

* i_err internal nodes
.nodeset V(xmod0.i_err_0)=0.05  V(xmod0.i_err_1)=0.05  V(xmod0.i_err_2)=0.05  V(xmod0.i_err_3)=0.05  V(xmod0.i_err_4)=0.05  V(xmod0.i_err_5)=0.05  V(xmod0.i_err_6)=0.05  V(xmod0.i_err_7)=0.05  V(xmod0.i_err_8)=0.05  V(xmod0.i_err_9)=0.05  V(xmod0.i_err_10)=0.05  V(xmod0.i_err_11)=0.05  V(xmod0.i_err_12)=0.05  V(xmod0.i_err_13)=0.05  V(xmod0.i_err_14)=0.05  V(xmod0.i_err_15)=0.05
.nodeset V(xmod1.i_err_0)=0.05  V(xmod1.i_err_1)=0.05  V(xmod1.i_err_2)=0.05  V(xmod1.i_err_3)=0.05  V(xmod1.i_err_4)=0.05  V(xmod1.i_err_5)=0.05  V(xmod1.i_err_6)=0.05  V(xmod1.i_err_7)=0.05  V(xmod1.i_err_8)=0.05  V(xmod1.i_err_9)=0.05  V(xmod1.i_err_10)=0.05  V(xmod1.i_err_11)=0.05  V(xmod1.i_err_12)=0.05  V(xmod1.i_err_13)=0.05  V(xmod1.i_err_14)=0.05  V(xmod1.i_err_15)=0.05
.nodeset V(xmod2.i_err_0)=0.05  V(xmod2.i_err_1)=0.05  V(xmod2.i_err_2)=0.05  V(xmod2.i_err_3)=0.05  V(xmod2.i_err_4)=0.05  V(xmod2.i_err_5)=0.05  V(xmod2.i_err_6)=0.05  V(xmod2.i_err_7)=0.05  V(xmod2.i_err_8)=0.05  V(xmod2.i_err_9)=0.05  V(xmod2.i_err_10)=0.05  V(xmod2.i_err_11)=0.05  V(xmod2.i_err_12)=0.05  V(xmod2.i_err_13)=0.05  V(xmod2.i_err_14)=0.05  V(xmod2.i_err_15)=0.05
.nodeset V(xmod3.i_err_0)=0.05  V(xmod3.i_err_1)=0.05  V(xmod3.i_err_2)=0.05  V(xmod3.i_err_3)=0.05  V(xmod3.i_err_4)=0.05  V(xmod3.i_err_5)=0.05  V(xmod3.i_err_6)=0.05  V(xmod3.i_err_7)=0.05  V(xmod3.i_err_8)=0.05  V(xmod3.i_err_9)=0.05  V(xmod3.i_err_10)=0.05  V(xmod3.i_err_11)=0.05  V(xmod3.i_err_12)=0.05  V(xmod3.i_err_13)=0.05  V(xmod3.i_err_14)=0.05  V(xmod3.i_err_15)=0.05

* Weight nodes: 4 × 16 × 16 = 1024 cells
.nodeset V(xmod0.xarray.vw_0_0)=0.75  V(xmod0.xarray.vw_0_1)=0.75  V(xmod0.xarray.vw_0_2)=0.75  V(xmod0.xarray.vw_0_3)=0.75  V(xmod0.xarray.vw_0_4)=0.75  V(xmod0.xarray.vw_0_5)=0.75  V(xmod0.xarray.vw_0_6)=0.75  V(xmod0.xarray.vw_0_7)=0.75  V(xmod0.xarray.vw_0_8)=0.75  V(xmod0.xarray.vw_0_9)=0.75  V(xmod0.xarray.vw_0_10)=0.75  V(xmod0.xarray.vw_0_11)=0.75  V(xmod0.xarray.vw_0_12)=0.75  V(xmod0.xarray.vw_0_13)=0.75  V(xmod0.xarray.vw_0_14)=0.75  V(xmod0.xarray.vw_0_15)=0.75
.nodeset V(xmod0.xarray.vw_1_0)=0.75  V(xmod0.xarray.vw_1_1)=0.75  V(xmod0.xarray.vw_1_2)=0.75  V(xmod0.xarray.vw_1_3)=0.75  V(xmod0.xarray.vw_1_4)=0.75  V(xmod0.xarray.vw_1_5)=0.75  V(xmod0.xarray.vw_1_6)=0.75  V(xmod0.xarray.vw_1_7)=0.75  V(xmod0.xarray.vw_1_8)=0.75  V(xmod0.xarray.vw_1_9)=0.75  V(xmod0.xarray.vw_1_10)=0.75  V(xmod0.xarray.vw_1_11)=0.75  V(xmod0.xarray.vw_1_12)=0.75  V(xmod0.xarray.vw_1_13)=0.75  V(xmod0.xarray.vw_1_14)=0.75  V(xmod0.xarray.vw_1_15)=0.75
.nodeset V(xmod0.xarray.vw_2_0)=0.75  V(xmod0.xarray.vw_2_1)=0.75  V(xmod0.xarray.vw_2_2)=0.75  V(xmod0.xarray.vw_2_3)=0.75  V(xmod0.xarray.vw_2_4)=0.75  V(xmod0.xarray.vw_2_5)=0.75  V(xmod0.xarray.vw_2_6)=0.75  V(xmod0.xarray.vw_2_7)=0.75  V(xmod0.xarray.vw_2_8)=0.75  V(xmod0.xarray.vw_2_9)=0.75  V(xmod0.xarray.vw_2_10)=0.75  V(xmod0.xarray.vw_2_11)=0.75  V(xmod0.xarray.vw_2_12)=0.75  V(xmod0.xarray.vw_2_13)=0.75  V(xmod0.xarray.vw_2_14)=0.75  V(xmod0.xarray.vw_2_15)=0.75
.nodeset V(xmod0.xarray.vw_3_0)=0.75  V(xmod0.xarray.vw_3_1)=0.75  V(xmod0.xarray.vw_3_2)=0.75  V(xmod0.xarray.vw_3_3)=0.75  V(xmod0.xarray.vw_3_4)=0.75  V(xmod0.xarray.vw_3_5)=0.75  V(xmod0.xarray.vw_3_6)=0.75  V(xmod0.xarray.vw_3_7)=0.75  V(xmod0.xarray.vw_3_8)=0.75  V(xmod0.xarray.vw_3_9)=0.75  V(xmod0.xarray.vw_3_10)=0.75  V(xmod0.xarray.vw_3_11)=0.75  V(xmod0.xarray.vw_3_12)=0.75  V(xmod0.xarray.vw_3_13)=0.75  V(xmod0.xarray.vw_3_14)=0.75  V(xmod0.xarray.vw_3_15)=0.75
.nodeset V(xmod0.xarray.vw_4_0)=0.75  V(xmod0.xarray.vw_4_1)=0.75  V(xmod0.xarray.vw_4_2)=0.75  V(xmod0.xarray.vw_4_3)=0.75  V(xmod0.xarray.vw_4_4)=0.75  V(xmod0.xarray.vw_4_5)=0.75  V(xmod0.xarray.vw_4_6)=0.75  V(xmod0.xarray.vw_4_7)=0.75  V(xmod0.xarray.vw_4_8)=0.75  V(xmod0.xarray.vw_4_9)=0.75  V(xmod0.xarray.vw_4_10)=0.75  V(xmod0.xarray.vw_4_11)=0.75  V(xmod0.xarray.vw_4_12)=0.75  V(xmod0.xarray.vw_4_13)=0.75  V(xmod0.xarray.vw_4_14)=0.75  V(xmod0.xarray.vw_4_15)=0.75
.nodeset V(xmod0.xarray.vw_5_0)=0.75  V(xmod0.xarray.vw_5_1)=0.75  V(xmod0.xarray.vw_5_2)=0.75  V(xmod0.xarray.vw_5_3)=0.75  V(xmod0.xarray.vw_5_4)=0.75  V(xmod0.xarray.vw_5_5)=0.75  V(xmod0.xarray.vw_5_6)=0.75  V(xmod0.xarray.vw_5_7)=0.75  V(xmod0.xarray.vw_5_8)=0.75  V(xmod0.xarray.vw_5_9)=0.75  V(xmod0.xarray.vw_5_10)=0.75  V(xmod0.xarray.vw_5_11)=0.75  V(xmod0.xarray.vw_5_12)=0.75  V(xmod0.xarray.vw_5_13)=0.75  V(xmod0.xarray.vw_5_14)=0.75  V(xmod0.xarray.vw_5_15)=0.75
.nodeset V(xmod0.xarray.vw_6_0)=0.75  V(xmod0.xarray.vw_6_1)=0.75  V(xmod0.xarray.vw_6_2)=0.75  V(xmod0.xarray.vw_6_3)=0.75  V(xmod0.xarray.vw_6_4)=0.75  V(xmod0.xarray.vw_6_5)=0.75  V(xmod0.xarray.vw_6_6)=0.75  V(xmod0.xarray.vw_6_7)=0.75  V(xmod0.xarray.vw_6_8)=0.75  V(xmod0.xarray.vw_6_9)=0.75  V(xmod0.xarray.vw_6_10)=0.75  V(xmod0.xarray.vw_6_11)=0.75  V(xmod0.xarray.vw_6_12)=0.75  V(xmod0.xarray.vw_6_13)=0.75  V(xmod0.xarray.vw_6_14)=0.75  V(xmod0.xarray.vw_6_15)=0.75
.nodeset V(xmod0.xarray.vw_7_0)=0.75  V(xmod0.xarray.vw_7_1)=0.75  V(xmod0.xarray.vw_7_2)=0.75  V(xmod0.xarray.vw_7_3)=0.75  V(xmod0.xarray.vw_7_4)=0.75  V(xmod0.xarray.vw_7_5)=0.75  V(xmod0.xarray.vw_7_6)=0.75  V(xmod0.xarray.vw_7_7)=0.75  V(xmod0.xarray.vw_7_8)=0.75  V(xmod0.xarray.vw_7_9)=0.75  V(xmod0.xarray.vw_7_10)=0.75  V(xmod0.xarray.vw_7_11)=0.75  V(xmod0.xarray.vw_7_12)=0.75  V(xmod0.xarray.vw_7_13)=0.75  V(xmod0.xarray.vw_7_14)=0.75  V(xmod0.xarray.vw_7_15)=0.75
.nodeset V(xmod0.xarray.vw_8_0)=0.75  V(xmod0.xarray.vw_8_1)=0.75  V(xmod0.xarray.vw_8_2)=0.75  V(xmod0.xarray.vw_8_3)=0.75  V(xmod0.xarray.vw_8_4)=0.75  V(xmod0.xarray.vw_8_5)=0.75  V(xmod0.xarray.vw_8_6)=0.75  V(xmod0.xarray.vw_8_7)=0.75  V(xmod0.xarray.vw_8_8)=0.75  V(xmod0.xarray.vw_8_9)=0.75  V(xmod0.xarray.vw_8_10)=0.75  V(xmod0.xarray.vw_8_11)=0.75  V(xmod0.xarray.vw_8_12)=0.75  V(xmod0.xarray.vw_8_13)=0.75  V(xmod0.xarray.vw_8_14)=0.75  V(xmod0.xarray.vw_8_15)=0.75
.nodeset V(xmod0.xarray.vw_9_0)=0.75  V(xmod0.xarray.vw_9_1)=0.75  V(xmod0.xarray.vw_9_2)=0.75  V(xmod0.xarray.vw_9_3)=0.75  V(xmod0.xarray.vw_9_4)=0.75  V(xmod0.xarray.vw_9_5)=0.75  V(xmod0.xarray.vw_9_6)=0.75  V(xmod0.xarray.vw_9_7)=0.75  V(xmod0.xarray.vw_9_8)=0.75  V(xmod0.xarray.vw_9_9)=0.75  V(xmod0.xarray.vw_9_10)=0.75  V(xmod0.xarray.vw_9_11)=0.75  V(xmod0.xarray.vw_9_12)=0.75  V(xmod0.xarray.vw_9_13)=0.75  V(xmod0.xarray.vw_9_14)=0.75  V(xmod0.xarray.vw_9_15)=0.75
.nodeset V(xmod0.xarray.vw_10_0)=0.75  V(xmod0.xarray.vw_10_1)=0.75  V(xmod0.xarray.vw_10_2)=0.75  V(xmod0.xarray.vw_10_3)=0.75  V(xmod0.xarray.vw_10_4)=0.75  V(xmod0.xarray.vw_10_5)=0.75  V(xmod0.xarray.vw_10_6)=0.75  V(xmod0.xarray.vw_10_7)=0.75  V(xmod0.xarray.vw_10_8)=0.75  V(xmod0.xarray.vw_10_9)=0.75  V(xmod0.xarray.vw_10_10)=0.75  V(xmod0.xarray.vw_10_11)=0.75  V(xmod0.xarray.vw_10_12)=0.75  V(xmod0.xarray.vw_10_13)=0.75  V(xmod0.xarray.vw_10_14)=0.75  V(xmod0.xarray.vw_10_15)=0.75
.nodeset V(xmod0.xarray.vw_11_0)=0.75  V(xmod0.xarray.vw_11_1)=0.75  V(xmod0.xarray.vw_11_2)=0.75  V(xmod0.xarray.vw_11_3)=0.75  V(xmod0.xarray.vw_11_4)=0.75  V(xmod0.xarray.vw_11_5)=0.75  V(xmod0.xarray.vw_11_6)=0.75  V(xmod0.xarray.vw_11_7)=0.75  V(xmod0.xarray.vw_11_8)=0.75  V(xmod0.xarray.vw_11_9)=0.75  V(xmod0.xarray.vw_11_10)=0.75  V(xmod0.xarray.vw_11_11)=0.75  V(xmod0.xarray.vw_11_12)=0.75  V(xmod0.xarray.vw_11_13)=0.75  V(xmod0.xarray.vw_11_14)=0.75  V(xmod0.xarray.vw_11_15)=0.75
.nodeset V(xmod0.xarray.vw_12_0)=0.75  V(xmod0.xarray.vw_12_1)=0.75  V(xmod0.xarray.vw_12_2)=0.75  V(xmod0.xarray.vw_12_3)=0.75  V(xmod0.xarray.vw_12_4)=0.75  V(xmod0.xarray.vw_12_5)=0.75  V(xmod0.xarray.vw_12_6)=0.75  V(xmod0.xarray.vw_12_7)=0.75  V(xmod0.xarray.vw_12_8)=0.75  V(xmod0.xarray.vw_12_9)=0.75  V(xmod0.xarray.vw_12_10)=0.75  V(xmod0.xarray.vw_12_11)=0.75  V(xmod0.xarray.vw_12_12)=0.75  V(xmod0.xarray.vw_12_13)=0.75  V(xmod0.xarray.vw_12_14)=0.75  V(xmod0.xarray.vw_12_15)=0.75
.nodeset V(xmod0.xarray.vw_13_0)=0.75  V(xmod0.xarray.vw_13_1)=0.75  V(xmod0.xarray.vw_13_2)=0.75  V(xmod0.xarray.vw_13_3)=0.75  V(xmod0.xarray.vw_13_4)=0.75  V(xmod0.xarray.vw_13_5)=0.75  V(xmod0.xarray.vw_13_6)=0.75  V(xmod0.xarray.vw_13_7)=0.75  V(xmod0.xarray.vw_13_8)=0.75  V(xmod0.xarray.vw_13_9)=0.75  V(xmod0.xarray.vw_13_10)=0.75  V(xmod0.xarray.vw_13_11)=0.75  V(xmod0.xarray.vw_13_12)=0.75  V(xmod0.xarray.vw_13_13)=0.75  V(xmod0.xarray.vw_13_14)=0.75  V(xmod0.xarray.vw_13_15)=0.75
.nodeset V(xmod0.xarray.vw_14_0)=0.75  V(xmod0.xarray.vw_14_1)=0.75  V(xmod0.xarray.vw_14_2)=0.75  V(xmod0.xarray.vw_14_3)=0.75  V(xmod0.xarray.vw_14_4)=0.75  V(xmod0.xarray.vw_14_5)=0.75  V(xmod0.xarray.vw_14_6)=0.75  V(xmod0.xarray.vw_14_7)=0.75  V(xmod0.xarray.vw_14_8)=0.75  V(xmod0.xarray.vw_14_9)=0.75  V(xmod0.xarray.vw_14_10)=0.75  V(xmod0.xarray.vw_14_11)=0.75  V(xmod0.xarray.vw_14_12)=0.75  V(xmod0.xarray.vw_14_13)=0.75  V(xmod0.xarray.vw_14_14)=0.75  V(xmod0.xarray.vw_14_15)=0.75
.nodeset V(xmod0.xarray.vw_15_0)=0.75  V(xmod0.xarray.vw_15_1)=0.75  V(xmod0.xarray.vw_15_2)=0.75  V(xmod0.xarray.vw_15_3)=0.75  V(xmod0.xarray.vw_15_4)=0.75  V(xmod0.xarray.vw_15_5)=0.75  V(xmod0.xarray.vw_15_6)=0.75  V(xmod0.xarray.vw_15_7)=0.75  V(xmod0.xarray.vw_15_8)=0.75  V(xmod0.xarray.vw_15_9)=0.75  V(xmod0.xarray.vw_15_10)=0.75  V(xmod0.xarray.vw_15_11)=0.75  V(xmod0.xarray.vw_15_12)=0.75  V(xmod0.xarray.vw_15_13)=0.75  V(xmod0.xarray.vw_15_14)=0.75  V(xmod0.xarray.vw_15_15)=0.75
.nodeset V(xmod1.xarray.vw_0_0)=0.75  V(xmod1.xarray.vw_0_1)=0.75  V(xmod1.xarray.vw_0_2)=0.75  V(xmod1.xarray.vw_0_3)=0.75  V(xmod1.xarray.vw_0_4)=0.75  V(xmod1.xarray.vw_0_5)=0.75  V(xmod1.xarray.vw_0_6)=0.75  V(xmod1.xarray.vw_0_7)=0.75  V(xmod1.xarray.vw_0_8)=0.75  V(xmod1.xarray.vw_0_9)=0.75  V(xmod1.xarray.vw_0_10)=0.75  V(xmod1.xarray.vw_0_11)=0.75  V(xmod1.xarray.vw_0_12)=0.75  V(xmod1.xarray.vw_0_13)=0.75  V(xmod1.xarray.vw_0_14)=0.75  V(xmod1.xarray.vw_0_15)=0.75
.nodeset V(xmod1.xarray.vw_1_0)=0.75  V(xmod1.xarray.vw_1_1)=0.75  V(xmod1.xarray.vw_1_2)=0.75  V(xmod1.xarray.vw_1_3)=0.75  V(xmod1.xarray.vw_1_4)=0.75  V(xmod1.xarray.vw_1_5)=0.75  V(xmod1.xarray.vw_1_6)=0.75  V(xmod1.xarray.vw_1_7)=0.75  V(xmod1.xarray.vw_1_8)=0.75  V(xmod1.xarray.vw_1_9)=0.75  V(xmod1.xarray.vw_1_10)=0.75  V(xmod1.xarray.vw_1_11)=0.75  V(xmod1.xarray.vw_1_12)=0.75  V(xmod1.xarray.vw_1_13)=0.75  V(xmod1.xarray.vw_1_14)=0.75  V(xmod1.xarray.vw_1_15)=0.75
.nodeset V(xmod1.xarray.vw_2_0)=0.75  V(xmod1.xarray.vw_2_1)=0.75  V(xmod1.xarray.vw_2_2)=0.75  V(xmod1.xarray.vw_2_3)=0.75  V(xmod1.xarray.vw_2_4)=0.75  V(xmod1.xarray.vw_2_5)=0.75  V(xmod1.xarray.vw_2_6)=0.75  V(xmod1.xarray.vw_2_7)=0.75  V(xmod1.xarray.vw_2_8)=0.75  V(xmod1.xarray.vw_2_9)=0.75  V(xmod1.xarray.vw_2_10)=0.75  V(xmod1.xarray.vw_2_11)=0.75  V(xmod1.xarray.vw_2_12)=0.75  V(xmod1.xarray.vw_2_13)=0.75  V(xmod1.xarray.vw_2_14)=0.75  V(xmod1.xarray.vw_2_15)=0.75
.nodeset V(xmod1.xarray.vw_3_0)=0.75  V(xmod1.xarray.vw_3_1)=0.75  V(xmod1.xarray.vw_3_2)=0.75  V(xmod1.xarray.vw_3_3)=0.75  V(xmod1.xarray.vw_3_4)=0.75  V(xmod1.xarray.vw_3_5)=0.75  V(xmod1.xarray.vw_3_6)=0.75  V(xmod1.xarray.vw_3_7)=0.75  V(xmod1.xarray.vw_3_8)=0.75  V(xmod1.xarray.vw_3_9)=0.75  V(xmod1.xarray.vw_3_10)=0.75  V(xmod1.xarray.vw_3_11)=0.75  V(xmod1.xarray.vw_3_12)=0.75  V(xmod1.xarray.vw_3_13)=0.75  V(xmod1.xarray.vw_3_14)=0.75  V(xmod1.xarray.vw_3_15)=0.75
.nodeset V(xmod1.xarray.vw_4_0)=0.75  V(xmod1.xarray.vw_4_1)=0.75  V(xmod1.xarray.vw_4_2)=0.75  V(xmod1.xarray.vw_4_3)=0.75  V(xmod1.xarray.vw_4_4)=0.75  V(xmod1.xarray.vw_4_5)=0.75  V(xmod1.xarray.vw_4_6)=0.75  V(xmod1.xarray.vw_4_7)=0.75  V(xmod1.xarray.vw_4_8)=0.75  V(xmod1.xarray.vw_4_9)=0.75  V(xmod1.xarray.vw_4_10)=0.75  V(xmod1.xarray.vw_4_11)=0.75  V(xmod1.xarray.vw_4_12)=0.75  V(xmod1.xarray.vw_4_13)=0.75  V(xmod1.xarray.vw_4_14)=0.75  V(xmod1.xarray.vw_4_15)=0.75
.nodeset V(xmod1.xarray.vw_5_0)=0.75  V(xmod1.xarray.vw_5_1)=0.75  V(xmod1.xarray.vw_5_2)=0.75  V(xmod1.xarray.vw_5_3)=0.75  V(xmod1.xarray.vw_5_4)=0.75  V(xmod1.xarray.vw_5_5)=0.75  V(xmod1.xarray.vw_5_6)=0.75  V(xmod1.xarray.vw_5_7)=0.75  V(xmod1.xarray.vw_5_8)=0.75  V(xmod1.xarray.vw_5_9)=0.75  V(xmod1.xarray.vw_5_10)=0.75  V(xmod1.xarray.vw_5_11)=0.75  V(xmod1.xarray.vw_5_12)=0.75  V(xmod1.xarray.vw_5_13)=0.75  V(xmod1.xarray.vw_5_14)=0.75  V(xmod1.xarray.vw_5_15)=0.75
.nodeset V(xmod1.xarray.vw_6_0)=0.75  V(xmod1.xarray.vw_6_1)=0.75  V(xmod1.xarray.vw_6_2)=0.75  V(xmod1.xarray.vw_6_3)=0.75  V(xmod1.xarray.vw_6_4)=0.75  V(xmod1.xarray.vw_6_5)=0.75  V(xmod1.xarray.vw_6_6)=0.75  V(xmod1.xarray.vw_6_7)=0.75  V(xmod1.xarray.vw_6_8)=0.75  V(xmod1.xarray.vw_6_9)=0.75  V(xmod1.xarray.vw_6_10)=0.75  V(xmod1.xarray.vw_6_11)=0.75  V(xmod1.xarray.vw_6_12)=0.75  V(xmod1.xarray.vw_6_13)=0.75  V(xmod1.xarray.vw_6_14)=0.75  V(xmod1.xarray.vw_6_15)=0.75
.nodeset V(xmod1.xarray.vw_7_0)=0.75  V(xmod1.xarray.vw_7_1)=0.75  V(xmod1.xarray.vw_7_2)=0.75  V(xmod1.xarray.vw_7_3)=0.75  V(xmod1.xarray.vw_7_4)=0.75  V(xmod1.xarray.vw_7_5)=0.75  V(xmod1.xarray.vw_7_6)=0.75  V(xmod1.xarray.vw_7_7)=0.75  V(xmod1.xarray.vw_7_8)=0.75  V(xmod1.xarray.vw_7_9)=0.75  V(xmod1.xarray.vw_7_10)=0.75  V(xmod1.xarray.vw_7_11)=0.75  V(xmod1.xarray.vw_7_12)=0.75  V(xmod1.xarray.vw_7_13)=0.75  V(xmod1.xarray.vw_7_14)=0.75  V(xmod1.xarray.vw_7_15)=0.75
.nodeset V(xmod1.xarray.vw_8_0)=0.75  V(xmod1.xarray.vw_8_1)=0.75  V(xmod1.xarray.vw_8_2)=0.75  V(xmod1.xarray.vw_8_3)=0.75  V(xmod1.xarray.vw_8_4)=0.75  V(xmod1.xarray.vw_8_5)=0.75  V(xmod1.xarray.vw_8_6)=0.75  V(xmod1.xarray.vw_8_7)=0.75  V(xmod1.xarray.vw_8_8)=0.75  V(xmod1.xarray.vw_8_9)=0.75  V(xmod1.xarray.vw_8_10)=0.75  V(xmod1.xarray.vw_8_11)=0.75  V(xmod1.xarray.vw_8_12)=0.75  V(xmod1.xarray.vw_8_13)=0.75  V(xmod1.xarray.vw_8_14)=0.75  V(xmod1.xarray.vw_8_15)=0.75
.nodeset V(xmod1.xarray.vw_9_0)=0.75  V(xmod1.xarray.vw_9_1)=0.75  V(xmod1.xarray.vw_9_2)=0.75  V(xmod1.xarray.vw_9_3)=0.75  V(xmod1.xarray.vw_9_4)=0.75  V(xmod1.xarray.vw_9_5)=0.75  V(xmod1.xarray.vw_9_6)=0.75  V(xmod1.xarray.vw_9_7)=0.75  V(xmod1.xarray.vw_9_8)=0.75  V(xmod1.xarray.vw_9_9)=0.75  V(xmod1.xarray.vw_9_10)=0.75  V(xmod1.xarray.vw_9_11)=0.75  V(xmod1.xarray.vw_9_12)=0.75  V(xmod1.xarray.vw_9_13)=0.75  V(xmod1.xarray.vw_9_14)=0.75  V(xmod1.xarray.vw_9_15)=0.75
.nodeset V(xmod1.xarray.vw_10_0)=0.75  V(xmod1.xarray.vw_10_1)=0.75  V(xmod1.xarray.vw_10_2)=0.75  V(xmod1.xarray.vw_10_3)=0.75  V(xmod1.xarray.vw_10_4)=0.75  V(xmod1.xarray.vw_10_5)=0.75  V(xmod1.xarray.vw_10_6)=0.75  V(xmod1.xarray.vw_10_7)=0.75  V(xmod1.xarray.vw_10_8)=0.75  V(xmod1.xarray.vw_10_9)=0.75  V(xmod1.xarray.vw_10_10)=0.75  V(xmod1.xarray.vw_10_11)=0.75  V(xmod1.xarray.vw_10_12)=0.75  V(xmod1.xarray.vw_10_13)=0.75  V(xmod1.xarray.vw_10_14)=0.75  V(xmod1.xarray.vw_10_15)=0.75
.nodeset V(xmod1.xarray.vw_11_0)=0.75  V(xmod1.xarray.vw_11_1)=0.75  V(xmod1.xarray.vw_11_2)=0.75  V(xmod1.xarray.vw_11_3)=0.75  V(xmod1.xarray.vw_11_4)=0.75  V(xmod1.xarray.vw_11_5)=0.75  V(xmod1.xarray.vw_11_6)=0.75  V(xmod1.xarray.vw_11_7)=0.75  V(xmod1.xarray.vw_11_8)=0.75  V(xmod1.xarray.vw_11_9)=0.75  V(xmod1.xarray.vw_11_10)=0.75  V(xmod1.xarray.vw_11_11)=0.75  V(xmod1.xarray.vw_11_12)=0.75  V(xmod1.xarray.vw_11_13)=0.75  V(xmod1.xarray.vw_11_14)=0.75  V(xmod1.xarray.vw_11_15)=0.75
.nodeset V(xmod1.xarray.vw_12_0)=0.75  V(xmod1.xarray.vw_12_1)=0.75  V(xmod1.xarray.vw_12_2)=0.75  V(xmod1.xarray.vw_12_3)=0.75  V(xmod1.xarray.vw_12_4)=0.75  V(xmod1.xarray.vw_12_5)=0.75  V(xmod1.xarray.vw_12_6)=0.75  V(xmod1.xarray.vw_12_7)=0.75  V(xmod1.xarray.vw_12_8)=0.75  V(xmod1.xarray.vw_12_9)=0.75  V(xmod1.xarray.vw_12_10)=0.75  V(xmod1.xarray.vw_12_11)=0.75  V(xmod1.xarray.vw_12_12)=0.75  V(xmod1.xarray.vw_12_13)=0.75  V(xmod1.xarray.vw_12_14)=0.75  V(xmod1.xarray.vw_12_15)=0.75
.nodeset V(xmod1.xarray.vw_13_0)=0.75  V(xmod1.xarray.vw_13_1)=0.75  V(xmod1.xarray.vw_13_2)=0.75  V(xmod1.xarray.vw_13_3)=0.75  V(xmod1.xarray.vw_13_4)=0.75  V(xmod1.xarray.vw_13_5)=0.75  V(xmod1.xarray.vw_13_6)=0.75  V(xmod1.xarray.vw_13_7)=0.75  V(xmod1.xarray.vw_13_8)=0.75  V(xmod1.xarray.vw_13_9)=0.75  V(xmod1.xarray.vw_13_10)=0.75  V(xmod1.xarray.vw_13_11)=0.75  V(xmod1.xarray.vw_13_12)=0.75  V(xmod1.xarray.vw_13_13)=0.75  V(xmod1.xarray.vw_13_14)=0.75  V(xmod1.xarray.vw_13_15)=0.75
.nodeset V(xmod1.xarray.vw_14_0)=0.75  V(xmod1.xarray.vw_14_1)=0.75  V(xmod1.xarray.vw_14_2)=0.75  V(xmod1.xarray.vw_14_3)=0.75  V(xmod1.xarray.vw_14_4)=0.75  V(xmod1.xarray.vw_14_5)=0.75  V(xmod1.xarray.vw_14_6)=0.75  V(xmod1.xarray.vw_14_7)=0.75  V(xmod1.xarray.vw_14_8)=0.75  V(xmod1.xarray.vw_14_9)=0.75  V(xmod1.xarray.vw_14_10)=0.75  V(xmod1.xarray.vw_14_11)=0.75  V(xmod1.xarray.vw_14_12)=0.75  V(xmod1.xarray.vw_14_13)=0.75  V(xmod1.xarray.vw_14_14)=0.75  V(xmod1.xarray.vw_14_15)=0.75
.nodeset V(xmod1.xarray.vw_15_0)=0.75  V(xmod1.xarray.vw_15_1)=0.75  V(xmod1.xarray.vw_15_2)=0.75  V(xmod1.xarray.vw_15_3)=0.75  V(xmod1.xarray.vw_15_4)=0.75  V(xmod1.xarray.vw_15_5)=0.75  V(xmod1.xarray.vw_15_6)=0.75  V(xmod1.xarray.vw_15_7)=0.75  V(xmod1.xarray.vw_15_8)=0.75  V(xmod1.xarray.vw_15_9)=0.75  V(xmod1.xarray.vw_15_10)=0.75  V(xmod1.xarray.vw_15_11)=0.75  V(xmod1.xarray.vw_15_12)=0.75  V(xmod1.xarray.vw_15_13)=0.75  V(xmod1.xarray.vw_15_14)=0.75  V(xmod1.xarray.vw_15_15)=0.75
.nodeset V(xmod2.xarray.vw_0_0)=0.75  V(xmod2.xarray.vw_0_1)=0.75  V(xmod2.xarray.vw_0_2)=0.75  V(xmod2.xarray.vw_0_3)=0.75  V(xmod2.xarray.vw_0_4)=0.75  V(xmod2.xarray.vw_0_5)=0.75  V(xmod2.xarray.vw_0_6)=0.75  V(xmod2.xarray.vw_0_7)=0.75  V(xmod2.xarray.vw_0_8)=0.75  V(xmod2.xarray.vw_0_9)=0.75  V(xmod2.xarray.vw_0_10)=0.75  V(xmod2.xarray.vw_0_11)=0.75  V(xmod2.xarray.vw_0_12)=0.75  V(xmod2.xarray.vw_0_13)=0.75  V(xmod2.xarray.vw_0_14)=0.75  V(xmod2.xarray.vw_0_15)=0.75
.nodeset V(xmod2.xarray.vw_1_0)=0.75  V(xmod2.xarray.vw_1_1)=0.75  V(xmod2.xarray.vw_1_2)=0.75  V(xmod2.xarray.vw_1_3)=0.75  V(xmod2.xarray.vw_1_4)=0.75  V(xmod2.xarray.vw_1_5)=0.75  V(xmod2.xarray.vw_1_6)=0.75  V(xmod2.xarray.vw_1_7)=0.75  V(xmod2.xarray.vw_1_8)=0.75  V(xmod2.xarray.vw_1_9)=0.75  V(xmod2.xarray.vw_1_10)=0.75  V(xmod2.xarray.vw_1_11)=0.75  V(xmod2.xarray.vw_1_12)=0.75  V(xmod2.xarray.vw_1_13)=0.75  V(xmod2.xarray.vw_1_14)=0.75  V(xmod2.xarray.vw_1_15)=0.75
.nodeset V(xmod2.xarray.vw_2_0)=0.75  V(xmod2.xarray.vw_2_1)=0.75  V(xmod2.xarray.vw_2_2)=0.75  V(xmod2.xarray.vw_2_3)=0.75  V(xmod2.xarray.vw_2_4)=0.75  V(xmod2.xarray.vw_2_5)=0.75  V(xmod2.xarray.vw_2_6)=0.75  V(xmod2.xarray.vw_2_7)=0.75  V(xmod2.xarray.vw_2_8)=0.75  V(xmod2.xarray.vw_2_9)=0.75  V(xmod2.xarray.vw_2_10)=0.75  V(xmod2.xarray.vw_2_11)=0.75  V(xmod2.xarray.vw_2_12)=0.75  V(xmod2.xarray.vw_2_13)=0.75  V(xmod2.xarray.vw_2_14)=0.75  V(xmod2.xarray.vw_2_15)=0.75
.nodeset V(xmod2.xarray.vw_3_0)=0.75  V(xmod2.xarray.vw_3_1)=0.75  V(xmod2.xarray.vw_3_2)=0.75  V(xmod2.xarray.vw_3_3)=0.75  V(xmod2.xarray.vw_3_4)=0.75  V(xmod2.xarray.vw_3_5)=0.75  V(xmod2.xarray.vw_3_6)=0.75  V(xmod2.xarray.vw_3_7)=0.75  V(xmod2.xarray.vw_3_8)=0.75  V(xmod2.xarray.vw_3_9)=0.75  V(xmod2.xarray.vw_3_10)=0.75  V(xmod2.xarray.vw_3_11)=0.75  V(xmod2.xarray.vw_3_12)=0.75  V(xmod2.xarray.vw_3_13)=0.75  V(xmod2.xarray.vw_3_14)=0.75  V(xmod2.xarray.vw_3_15)=0.75
.nodeset V(xmod2.xarray.vw_4_0)=0.75  V(xmod2.xarray.vw_4_1)=0.75  V(xmod2.xarray.vw_4_2)=0.75  V(xmod2.xarray.vw_4_3)=0.75  V(xmod2.xarray.vw_4_4)=0.75  V(xmod2.xarray.vw_4_5)=0.75  V(xmod2.xarray.vw_4_6)=0.75  V(xmod2.xarray.vw_4_7)=0.75  V(xmod2.xarray.vw_4_8)=0.75  V(xmod2.xarray.vw_4_9)=0.75  V(xmod2.xarray.vw_4_10)=0.75  V(xmod2.xarray.vw_4_11)=0.75  V(xmod2.xarray.vw_4_12)=0.75  V(xmod2.xarray.vw_4_13)=0.75  V(xmod2.xarray.vw_4_14)=0.75  V(xmod2.xarray.vw_4_15)=0.75
.nodeset V(xmod2.xarray.vw_5_0)=0.75  V(xmod2.xarray.vw_5_1)=0.75  V(xmod2.xarray.vw_5_2)=0.75  V(xmod2.xarray.vw_5_3)=0.75  V(xmod2.xarray.vw_5_4)=0.75  V(xmod2.xarray.vw_5_5)=0.75  V(xmod2.xarray.vw_5_6)=0.75  V(xmod2.xarray.vw_5_7)=0.75  V(xmod2.xarray.vw_5_8)=0.75  V(xmod2.xarray.vw_5_9)=0.75  V(xmod2.xarray.vw_5_10)=0.75  V(xmod2.xarray.vw_5_11)=0.75  V(xmod2.xarray.vw_5_12)=0.75  V(xmod2.xarray.vw_5_13)=0.75  V(xmod2.xarray.vw_5_14)=0.75  V(xmod2.xarray.vw_5_15)=0.75
.nodeset V(xmod2.xarray.vw_6_0)=0.75  V(xmod2.xarray.vw_6_1)=0.75  V(xmod2.xarray.vw_6_2)=0.75  V(xmod2.xarray.vw_6_3)=0.75  V(xmod2.xarray.vw_6_4)=0.75  V(xmod2.xarray.vw_6_5)=0.75  V(xmod2.xarray.vw_6_6)=0.75  V(xmod2.xarray.vw_6_7)=0.75  V(xmod2.xarray.vw_6_8)=0.75  V(xmod2.xarray.vw_6_9)=0.75  V(xmod2.xarray.vw_6_10)=0.75  V(xmod2.xarray.vw_6_11)=0.75  V(xmod2.xarray.vw_6_12)=0.75  V(xmod2.xarray.vw_6_13)=0.75  V(xmod2.xarray.vw_6_14)=0.75  V(xmod2.xarray.vw_6_15)=0.75
.nodeset V(xmod2.xarray.vw_7_0)=0.75  V(xmod2.xarray.vw_7_1)=0.75  V(xmod2.xarray.vw_7_2)=0.75  V(xmod2.xarray.vw_7_3)=0.75  V(xmod2.xarray.vw_7_4)=0.75  V(xmod2.xarray.vw_7_5)=0.75  V(xmod2.xarray.vw_7_6)=0.75  V(xmod2.xarray.vw_7_7)=0.75  V(xmod2.xarray.vw_7_8)=0.75  V(xmod2.xarray.vw_7_9)=0.75  V(xmod2.xarray.vw_7_10)=0.75  V(xmod2.xarray.vw_7_11)=0.75  V(xmod2.xarray.vw_7_12)=0.75  V(xmod2.xarray.vw_7_13)=0.75  V(xmod2.xarray.vw_7_14)=0.75  V(xmod2.xarray.vw_7_15)=0.75
.nodeset V(xmod2.xarray.vw_8_0)=0.75  V(xmod2.xarray.vw_8_1)=0.75  V(xmod2.xarray.vw_8_2)=0.75  V(xmod2.xarray.vw_8_3)=0.75  V(xmod2.xarray.vw_8_4)=0.75  V(xmod2.xarray.vw_8_5)=0.75  V(xmod2.xarray.vw_8_6)=0.75  V(xmod2.xarray.vw_8_7)=0.75  V(xmod2.xarray.vw_8_8)=0.75  V(xmod2.xarray.vw_8_9)=0.75  V(xmod2.xarray.vw_8_10)=0.75  V(xmod2.xarray.vw_8_11)=0.75  V(xmod2.xarray.vw_8_12)=0.75  V(xmod2.xarray.vw_8_13)=0.75  V(xmod2.xarray.vw_8_14)=0.75  V(xmod2.xarray.vw_8_15)=0.75
.nodeset V(xmod2.xarray.vw_9_0)=0.75  V(xmod2.xarray.vw_9_1)=0.75  V(xmod2.xarray.vw_9_2)=0.75  V(xmod2.xarray.vw_9_3)=0.75  V(xmod2.xarray.vw_9_4)=0.75  V(xmod2.xarray.vw_9_5)=0.75  V(xmod2.xarray.vw_9_6)=0.75  V(xmod2.xarray.vw_9_7)=0.75  V(xmod2.xarray.vw_9_8)=0.75  V(xmod2.xarray.vw_9_9)=0.75  V(xmod2.xarray.vw_9_10)=0.75  V(xmod2.xarray.vw_9_11)=0.75  V(xmod2.xarray.vw_9_12)=0.75  V(xmod2.xarray.vw_9_13)=0.75  V(xmod2.xarray.vw_9_14)=0.75  V(xmod2.xarray.vw_9_15)=0.75
.nodeset V(xmod2.xarray.vw_10_0)=0.75  V(xmod2.xarray.vw_10_1)=0.75  V(xmod2.xarray.vw_10_2)=0.75  V(xmod2.xarray.vw_10_3)=0.75  V(xmod2.xarray.vw_10_4)=0.75  V(xmod2.xarray.vw_10_5)=0.75  V(xmod2.xarray.vw_10_6)=0.75  V(xmod2.xarray.vw_10_7)=0.75  V(xmod2.xarray.vw_10_8)=0.75  V(xmod2.xarray.vw_10_9)=0.75  V(xmod2.xarray.vw_10_10)=0.75  V(xmod2.xarray.vw_10_11)=0.75  V(xmod2.xarray.vw_10_12)=0.75  V(xmod2.xarray.vw_10_13)=0.75  V(xmod2.xarray.vw_10_14)=0.75  V(xmod2.xarray.vw_10_15)=0.75
.nodeset V(xmod2.xarray.vw_11_0)=0.75  V(xmod2.xarray.vw_11_1)=0.75  V(xmod2.xarray.vw_11_2)=0.75  V(xmod2.xarray.vw_11_3)=0.75  V(xmod2.xarray.vw_11_4)=0.75  V(xmod2.xarray.vw_11_5)=0.75  V(xmod2.xarray.vw_11_6)=0.75  V(xmod2.xarray.vw_11_7)=0.75  V(xmod2.xarray.vw_11_8)=0.75  V(xmod2.xarray.vw_11_9)=0.75  V(xmod2.xarray.vw_11_10)=0.75  V(xmod2.xarray.vw_11_11)=0.75  V(xmod2.xarray.vw_11_12)=0.75  V(xmod2.xarray.vw_11_13)=0.75  V(xmod2.xarray.vw_11_14)=0.75  V(xmod2.xarray.vw_11_15)=0.75
.nodeset V(xmod2.xarray.vw_12_0)=0.75  V(xmod2.xarray.vw_12_1)=0.75  V(xmod2.xarray.vw_12_2)=0.75  V(xmod2.xarray.vw_12_3)=0.75  V(xmod2.xarray.vw_12_4)=0.75  V(xmod2.xarray.vw_12_5)=0.75  V(xmod2.xarray.vw_12_6)=0.75  V(xmod2.xarray.vw_12_7)=0.75  V(xmod2.xarray.vw_12_8)=0.75  V(xmod2.xarray.vw_12_9)=0.75  V(xmod2.xarray.vw_12_10)=0.75  V(xmod2.xarray.vw_12_11)=0.75  V(xmod2.xarray.vw_12_12)=0.75  V(xmod2.xarray.vw_12_13)=0.75  V(xmod2.xarray.vw_12_14)=0.75  V(xmod2.xarray.vw_12_15)=0.75
.nodeset V(xmod2.xarray.vw_13_0)=0.75  V(xmod2.xarray.vw_13_1)=0.75  V(xmod2.xarray.vw_13_2)=0.75  V(xmod2.xarray.vw_13_3)=0.75  V(xmod2.xarray.vw_13_4)=0.75  V(xmod2.xarray.vw_13_5)=0.75  V(xmod2.xarray.vw_13_6)=0.75  V(xmod2.xarray.vw_13_7)=0.75  V(xmod2.xarray.vw_13_8)=0.75  V(xmod2.xarray.vw_13_9)=0.75  V(xmod2.xarray.vw_13_10)=0.75  V(xmod2.xarray.vw_13_11)=0.75  V(xmod2.xarray.vw_13_12)=0.75  V(xmod2.xarray.vw_13_13)=0.75  V(xmod2.xarray.vw_13_14)=0.75  V(xmod2.xarray.vw_13_15)=0.75
.nodeset V(xmod2.xarray.vw_14_0)=0.75  V(xmod2.xarray.vw_14_1)=0.75  V(xmod2.xarray.vw_14_2)=0.75  V(xmod2.xarray.vw_14_3)=0.75  V(xmod2.xarray.vw_14_4)=0.75  V(xmod2.xarray.vw_14_5)=0.75  V(xmod2.xarray.vw_14_6)=0.75  V(xmod2.xarray.vw_14_7)=0.75  V(xmod2.xarray.vw_14_8)=0.75  V(xmod2.xarray.vw_14_9)=0.75  V(xmod2.xarray.vw_14_10)=0.75  V(xmod2.xarray.vw_14_11)=0.75  V(xmod2.xarray.vw_14_12)=0.75  V(xmod2.xarray.vw_14_13)=0.75  V(xmod2.xarray.vw_14_14)=0.75  V(xmod2.xarray.vw_14_15)=0.75
.nodeset V(xmod2.xarray.vw_15_0)=0.75  V(xmod2.xarray.vw_15_1)=0.75  V(xmod2.xarray.vw_15_2)=0.75  V(xmod2.xarray.vw_15_3)=0.75  V(xmod2.xarray.vw_15_4)=0.75  V(xmod2.xarray.vw_15_5)=0.75  V(xmod2.xarray.vw_15_6)=0.75  V(xmod2.xarray.vw_15_7)=0.75  V(xmod2.xarray.vw_15_8)=0.75  V(xmod2.xarray.vw_15_9)=0.75  V(xmod2.xarray.vw_15_10)=0.75  V(xmod2.xarray.vw_15_11)=0.75  V(xmod2.xarray.vw_15_12)=0.75  V(xmod2.xarray.vw_15_13)=0.75  V(xmod2.xarray.vw_15_14)=0.75  V(xmod2.xarray.vw_15_15)=0.75
.nodeset V(xmod3.xarray.vw_0_0)=0.75  V(xmod3.xarray.vw_0_1)=0.75  V(xmod3.xarray.vw_0_2)=0.75  V(xmod3.xarray.vw_0_3)=0.75  V(xmod3.xarray.vw_0_4)=0.75  V(xmod3.xarray.vw_0_5)=0.75  V(xmod3.xarray.vw_0_6)=0.75  V(xmod3.xarray.vw_0_7)=0.75  V(xmod3.xarray.vw_0_8)=0.75  V(xmod3.xarray.vw_0_9)=0.75  V(xmod3.xarray.vw_0_10)=0.75  V(xmod3.xarray.vw_0_11)=0.75  V(xmod3.xarray.vw_0_12)=0.75  V(xmod3.xarray.vw_0_13)=0.75  V(xmod3.xarray.vw_0_14)=0.75  V(xmod3.xarray.vw_0_15)=0.75
.nodeset V(xmod3.xarray.vw_1_0)=0.75  V(xmod3.xarray.vw_1_1)=0.75  V(xmod3.xarray.vw_1_2)=0.75  V(xmod3.xarray.vw_1_3)=0.75  V(xmod3.xarray.vw_1_4)=0.75  V(xmod3.xarray.vw_1_5)=0.75  V(xmod3.xarray.vw_1_6)=0.75  V(xmod3.xarray.vw_1_7)=0.75  V(xmod3.xarray.vw_1_8)=0.75  V(xmod3.xarray.vw_1_9)=0.75  V(xmod3.xarray.vw_1_10)=0.75  V(xmod3.xarray.vw_1_11)=0.75  V(xmod3.xarray.vw_1_12)=0.75  V(xmod3.xarray.vw_1_13)=0.75  V(xmod3.xarray.vw_1_14)=0.75  V(xmod3.xarray.vw_1_15)=0.75
.nodeset V(xmod3.xarray.vw_2_0)=0.75  V(xmod3.xarray.vw_2_1)=0.75  V(xmod3.xarray.vw_2_2)=0.75  V(xmod3.xarray.vw_2_3)=0.75  V(xmod3.xarray.vw_2_4)=0.75  V(xmod3.xarray.vw_2_5)=0.75  V(xmod3.xarray.vw_2_6)=0.75  V(xmod3.xarray.vw_2_7)=0.75  V(xmod3.xarray.vw_2_8)=0.75  V(xmod3.xarray.vw_2_9)=0.75  V(xmod3.xarray.vw_2_10)=0.75  V(xmod3.xarray.vw_2_11)=0.75  V(xmod3.xarray.vw_2_12)=0.75  V(xmod3.xarray.vw_2_13)=0.75  V(xmod3.xarray.vw_2_14)=0.75  V(xmod3.xarray.vw_2_15)=0.75
.nodeset V(xmod3.xarray.vw_3_0)=0.75  V(xmod3.xarray.vw_3_1)=0.75  V(xmod3.xarray.vw_3_2)=0.75  V(xmod3.xarray.vw_3_3)=0.75  V(xmod3.xarray.vw_3_4)=0.75  V(xmod3.xarray.vw_3_5)=0.75  V(xmod3.xarray.vw_3_6)=0.75  V(xmod3.xarray.vw_3_7)=0.75  V(xmod3.xarray.vw_3_8)=0.75  V(xmod3.xarray.vw_3_9)=0.75  V(xmod3.xarray.vw_3_10)=0.75  V(xmod3.xarray.vw_3_11)=0.75  V(xmod3.xarray.vw_3_12)=0.75  V(xmod3.xarray.vw_3_13)=0.75  V(xmod3.xarray.vw_3_14)=0.75  V(xmod3.xarray.vw_3_15)=0.75
.nodeset V(xmod3.xarray.vw_4_0)=0.75  V(xmod3.xarray.vw_4_1)=0.75  V(xmod3.xarray.vw_4_2)=0.75  V(xmod3.xarray.vw_4_3)=0.75  V(xmod3.xarray.vw_4_4)=0.75  V(xmod3.xarray.vw_4_5)=0.75  V(xmod3.xarray.vw_4_6)=0.75  V(xmod3.xarray.vw_4_7)=0.75  V(xmod3.xarray.vw_4_8)=0.75  V(xmod3.xarray.vw_4_9)=0.75  V(xmod3.xarray.vw_4_10)=0.75  V(xmod3.xarray.vw_4_11)=0.75  V(xmod3.xarray.vw_4_12)=0.75  V(xmod3.xarray.vw_4_13)=0.75  V(xmod3.xarray.vw_4_14)=0.75  V(xmod3.xarray.vw_4_15)=0.75
.nodeset V(xmod3.xarray.vw_5_0)=0.75  V(xmod3.xarray.vw_5_1)=0.75  V(xmod3.xarray.vw_5_2)=0.75  V(xmod3.xarray.vw_5_3)=0.75  V(xmod3.xarray.vw_5_4)=0.75  V(xmod3.xarray.vw_5_5)=0.75  V(xmod3.xarray.vw_5_6)=0.75  V(xmod3.xarray.vw_5_7)=0.75  V(xmod3.xarray.vw_5_8)=0.75  V(xmod3.xarray.vw_5_9)=0.75  V(xmod3.xarray.vw_5_10)=0.75  V(xmod3.xarray.vw_5_11)=0.75  V(xmod3.xarray.vw_5_12)=0.75  V(xmod3.xarray.vw_5_13)=0.75  V(xmod3.xarray.vw_5_14)=0.75  V(xmod3.xarray.vw_5_15)=0.75
.nodeset V(xmod3.xarray.vw_6_0)=0.75  V(xmod3.xarray.vw_6_1)=0.75  V(xmod3.xarray.vw_6_2)=0.75  V(xmod3.xarray.vw_6_3)=0.75  V(xmod3.xarray.vw_6_4)=0.75  V(xmod3.xarray.vw_6_5)=0.75  V(xmod3.xarray.vw_6_6)=0.75  V(xmod3.xarray.vw_6_7)=0.75  V(xmod3.xarray.vw_6_8)=0.75  V(xmod3.xarray.vw_6_9)=0.75  V(xmod3.xarray.vw_6_10)=0.75  V(xmod3.xarray.vw_6_11)=0.75  V(xmod3.xarray.vw_6_12)=0.75  V(xmod3.xarray.vw_6_13)=0.75  V(xmod3.xarray.vw_6_14)=0.75  V(xmod3.xarray.vw_6_15)=0.75
.nodeset V(xmod3.xarray.vw_7_0)=0.75  V(xmod3.xarray.vw_7_1)=0.75  V(xmod3.xarray.vw_7_2)=0.75  V(xmod3.xarray.vw_7_3)=0.75  V(xmod3.xarray.vw_7_4)=0.75  V(xmod3.xarray.vw_7_5)=0.75  V(xmod3.xarray.vw_7_6)=0.75  V(xmod3.xarray.vw_7_7)=0.75  V(xmod3.xarray.vw_7_8)=0.75  V(xmod3.xarray.vw_7_9)=0.75  V(xmod3.xarray.vw_7_10)=0.75  V(xmod3.xarray.vw_7_11)=0.75  V(xmod3.xarray.vw_7_12)=0.75  V(xmod3.xarray.vw_7_13)=0.75  V(xmod3.xarray.vw_7_14)=0.75  V(xmod3.xarray.vw_7_15)=0.75
.nodeset V(xmod3.xarray.vw_8_0)=0.75  V(xmod3.xarray.vw_8_1)=0.75  V(xmod3.xarray.vw_8_2)=0.75  V(xmod3.xarray.vw_8_3)=0.75  V(xmod3.xarray.vw_8_4)=0.75  V(xmod3.xarray.vw_8_5)=0.75  V(xmod3.xarray.vw_8_6)=0.75  V(xmod3.xarray.vw_8_7)=0.75  V(xmod3.xarray.vw_8_8)=0.75  V(xmod3.xarray.vw_8_9)=0.75  V(xmod3.xarray.vw_8_10)=0.75  V(xmod3.xarray.vw_8_11)=0.75  V(xmod3.xarray.vw_8_12)=0.75  V(xmod3.xarray.vw_8_13)=0.75  V(xmod3.xarray.vw_8_14)=0.75  V(xmod3.xarray.vw_8_15)=0.75
.nodeset V(xmod3.xarray.vw_9_0)=0.75  V(xmod3.xarray.vw_9_1)=0.75  V(xmod3.xarray.vw_9_2)=0.75  V(xmod3.xarray.vw_9_3)=0.75  V(xmod3.xarray.vw_9_4)=0.75  V(xmod3.xarray.vw_9_5)=0.75  V(xmod3.xarray.vw_9_6)=0.75  V(xmod3.xarray.vw_9_7)=0.75  V(xmod3.xarray.vw_9_8)=0.75  V(xmod3.xarray.vw_9_9)=0.75  V(xmod3.xarray.vw_9_10)=0.75  V(xmod3.xarray.vw_9_11)=0.75  V(xmod3.xarray.vw_9_12)=0.75  V(xmod3.xarray.vw_9_13)=0.75  V(xmod3.xarray.vw_9_14)=0.75  V(xmod3.xarray.vw_9_15)=0.75
.nodeset V(xmod3.xarray.vw_10_0)=0.75  V(xmod3.xarray.vw_10_1)=0.75  V(xmod3.xarray.vw_10_2)=0.75  V(xmod3.xarray.vw_10_3)=0.75  V(xmod3.xarray.vw_10_4)=0.75  V(xmod3.xarray.vw_10_5)=0.75  V(xmod3.xarray.vw_10_6)=0.75  V(xmod3.xarray.vw_10_7)=0.75  V(xmod3.xarray.vw_10_8)=0.75  V(xmod3.xarray.vw_10_9)=0.75  V(xmod3.xarray.vw_10_10)=0.75  V(xmod3.xarray.vw_10_11)=0.75  V(xmod3.xarray.vw_10_12)=0.75  V(xmod3.xarray.vw_10_13)=0.75  V(xmod3.xarray.vw_10_14)=0.75  V(xmod3.xarray.vw_10_15)=0.75
.nodeset V(xmod3.xarray.vw_11_0)=0.75  V(xmod3.xarray.vw_11_1)=0.75  V(xmod3.xarray.vw_11_2)=0.75  V(xmod3.xarray.vw_11_3)=0.75  V(xmod3.xarray.vw_11_4)=0.75  V(xmod3.xarray.vw_11_5)=0.75  V(xmod3.xarray.vw_11_6)=0.75  V(xmod3.xarray.vw_11_7)=0.75  V(xmod3.xarray.vw_11_8)=0.75  V(xmod3.xarray.vw_11_9)=0.75  V(xmod3.xarray.vw_11_10)=0.75  V(xmod3.xarray.vw_11_11)=0.75  V(xmod3.xarray.vw_11_12)=0.75  V(xmod3.xarray.vw_11_13)=0.75  V(xmod3.xarray.vw_11_14)=0.75  V(xmod3.xarray.vw_11_15)=0.75
.nodeset V(xmod3.xarray.vw_12_0)=0.75  V(xmod3.xarray.vw_12_1)=0.75  V(xmod3.xarray.vw_12_2)=0.75  V(xmod3.xarray.vw_12_3)=0.75  V(xmod3.xarray.vw_12_4)=0.75  V(xmod3.xarray.vw_12_5)=0.75  V(xmod3.xarray.vw_12_6)=0.75  V(xmod3.xarray.vw_12_7)=0.75  V(xmod3.xarray.vw_12_8)=0.75  V(xmod3.xarray.vw_12_9)=0.75  V(xmod3.xarray.vw_12_10)=0.75  V(xmod3.xarray.vw_12_11)=0.75  V(xmod3.xarray.vw_12_12)=0.75  V(xmod3.xarray.vw_12_13)=0.75  V(xmod3.xarray.vw_12_14)=0.75  V(xmod3.xarray.vw_12_15)=0.75
.nodeset V(xmod3.xarray.vw_13_0)=0.75  V(xmod3.xarray.vw_13_1)=0.75  V(xmod3.xarray.vw_13_2)=0.75  V(xmod3.xarray.vw_13_3)=0.75  V(xmod3.xarray.vw_13_4)=0.75  V(xmod3.xarray.vw_13_5)=0.75  V(xmod3.xarray.vw_13_6)=0.75  V(xmod3.xarray.vw_13_7)=0.75  V(xmod3.xarray.vw_13_8)=0.75  V(xmod3.xarray.vw_13_9)=0.75  V(xmod3.xarray.vw_13_10)=0.75  V(xmod3.xarray.vw_13_11)=0.75  V(xmod3.xarray.vw_13_12)=0.75  V(xmod3.xarray.vw_13_13)=0.75  V(xmod3.xarray.vw_13_14)=0.75  V(xmod3.xarray.vw_13_15)=0.75
.nodeset V(xmod3.xarray.vw_14_0)=0.75  V(xmod3.xarray.vw_14_1)=0.75  V(xmod3.xarray.vw_14_2)=0.75  V(xmod3.xarray.vw_14_3)=0.75  V(xmod3.xarray.vw_14_4)=0.75  V(xmod3.xarray.vw_14_5)=0.75  V(xmod3.xarray.vw_14_6)=0.75  V(xmod3.xarray.vw_14_7)=0.75  V(xmod3.xarray.vw_14_8)=0.75  V(xmod3.xarray.vw_14_9)=0.75  V(xmod3.xarray.vw_14_10)=0.75  V(xmod3.xarray.vw_14_11)=0.75  V(xmod3.xarray.vw_14_12)=0.75  V(xmod3.xarray.vw_14_13)=0.75  V(xmod3.xarray.vw_14_14)=0.75  V(xmod3.xarray.vw_14_15)=0.75
.nodeset V(xmod3.xarray.vw_15_0)=0.75  V(xmod3.xarray.vw_15_1)=0.75  V(xmod3.xarray.vw_15_2)=0.75  V(xmod3.xarray.vw_15_3)=0.75  V(xmod3.xarray.vw_15_4)=0.75  V(xmod3.xarray.vw_15_5)=0.75  V(xmod3.xarray.vw_15_6)=0.75  V(xmod3.xarray.vw_15_7)=0.75  V(xmod3.xarray.vw_15_8)=0.75  V(xmod3.xarray.vw_15_9)=0.75  V(xmod3.xarray.vw_15_10)=0.75  V(xmod3.xarray.vw_15_11)=0.75  V(xmod3.xarray.vw_15_12)=0.75  V(xmod3.xarray.vw_15_13)=0.75  V(xmod3.xarray.vw_15_14)=0.75  V(xmod3.xarray.vw_15_15)=0.75

* iwrite nodes: floating when WE=0
.nodeset V(xmod0.xarray.iwrite_0_0)=0.9  V(xmod0.xarray.iwrite_0_1)=0.9  V(xmod0.xarray.iwrite_0_2)=0.9  V(xmod0.xarray.iwrite_0_3)=0.9  V(xmod0.xarray.iwrite_0_4)=0.9  V(xmod0.xarray.iwrite_0_5)=0.9  V(xmod0.xarray.iwrite_0_6)=0.9  V(xmod0.xarray.iwrite_0_7)=0.9  V(xmod0.xarray.iwrite_0_8)=0.9  V(xmod0.xarray.iwrite_0_9)=0.9  V(xmod0.xarray.iwrite_0_10)=0.9  V(xmod0.xarray.iwrite_0_11)=0.9  V(xmod0.xarray.iwrite_0_12)=0.9  V(xmod0.xarray.iwrite_0_13)=0.9  V(xmod0.xarray.iwrite_0_14)=0.9  V(xmod0.xarray.iwrite_0_15)=0.9
.nodeset V(xmod0.xarray.iwrite_1_0)=0.9  V(xmod0.xarray.iwrite_1_1)=0.9  V(xmod0.xarray.iwrite_1_2)=0.9  V(xmod0.xarray.iwrite_1_3)=0.9  V(xmod0.xarray.iwrite_1_4)=0.9  V(xmod0.xarray.iwrite_1_5)=0.9  V(xmod0.xarray.iwrite_1_6)=0.9  V(xmod0.xarray.iwrite_1_7)=0.9  V(xmod0.xarray.iwrite_1_8)=0.9  V(xmod0.xarray.iwrite_1_9)=0.9  V(xmod0.xarray.iwrite_1_10)=0.9  V(xmod0.xarray.iwrite_1_11)=0.9  V(xmod0.xarray.iwrite_1_12)=0.9  V(xmod0.xarray.iwrite_1_13)=0.9  V(xmod0.xarray.iwrite_1_14)=0.9  V(xmod0.xarray.iwrite_1_15)=0.9
.nodeset V(xmod0.xarray.iwrite_2_0)=0.9  V(xmod0.xarray.iwrite_2_1)=0.9  V(xmod0.xarray.iwrite_2_2)=0.9  V(xmod0.xarray.iwrite_2_3)=0.9  V(xmod0.xarray.iwrite_2_4)=0.9  V(xmod0.xarray.iwrite_2_5)=0.9  V(xmod0.xarray.iwrite_2_6)=0.9  V(xmod0.xarray.iwrite_2_7)=0.9  V(xmod0.xarray.iwrite_2_8)=0.9  V(xmod0.xarray.iwrite_2_9)=0.9  V(xmod0.xarray.iwrite_2_10)=0.9  V(xmod0.xarray.iwrite_2_11)=0.9  V(xmod0.xarray.iwrite_2_12)=0.9  V(xmod0.xarray.iwrite_2_13)=0.9  V(xmod0.xarray.iwrite_2_14)=0.9  V(xmod0.xarray.iwrite_2_15)=0.9
.nodeset V(xmod0.xarray.iwrite_3_0)=0.9  V(xmod0.xarray.iwrite_3_1)=0.9  V(xmod0.xarray.iwrite_3_2)=0.9  V(xmod0.xarray.iwrite_3_3)=0.9  V(xmod0.xarray.iwrite_3_4)=0.9  V(xmod0.xarray.iwrite_3_5)=0.9  V(xmod0.xarray.iwrite_3_6)=0.9  V(xmod0.xarray.iwrite_3_7)=0.9  V(xmod0.xarray.iwrite_3_8)=0.9  V(xmod0.xarray.iwrite_3_9)=0.9  V(xmod0.xarray.iwrite_3_10)=0.9  V(xmod0.xarray.iwrite_3_11)=0.9  V(xmod0.xarray.iwrite_3_12)=0.9  V(xmod0.xarray.iwrite_3_13)=0.9  V(xmod0.xarray.iwrite_3_14)=0.9  V(xmod0.xarray.iwrite_3_15)=0.9
.nodeset V(xmod0.xarray.iwrite_4_0)=0.9  V(xmod0.xarray.iwrite_4_1)=0.9  V(xmod0.xarray.iwrite_4_2)=0.9  V(xmod0.xarray.iwrite_4_3)=0.9  V(xmod0.xarray.iwrite_4_4)=0.9  V(xmod0.xarray.iwrite_4_5)=0.9  V(xmod0.xarray.iwrite_4_6)=0.9  V(xmod0.xarray.iwrite_4_7)=0.9  V(xmod0.xarray.iwrite_4_8)=0.9  V(xmod0.xarray.iwrite_4_9)=0.9  V(xmod0.xarray.iwrite_4_10)=0.9  V(xmod0.xarray.iwrite_4_11)=0.9  V(xmod0.xarray.iwrite_4_12)=0.9  V(xmod0.xarray.iwrite_4_13)=0.9  V(xmod0.xarray.iwrite_4_14)=0.9  V(xmod0.xarray.iwrite_4_15)=0.9
.nodeset V(xmod0.xarray.iwrite_5_0)=0.9  V(xmod0.xarray.iwrite_5_1)=0.9  V(xmod0.xarray.iwrite_5_2)=0.9  V(xmod0.xarray.iwrite_5_3)=0.9  V(xmod0.xarray.iwrite_5_4)=0.9  V(xmod0.xarray.iwrite_5_5)=0.9  V(xmod0.xarray.iwrite_5_6)=0.9  V(xmod0.xarray.iwrite_5_7)=0.9  V(xmod0.xarray.iwrite_5_8)=0.9  V(xmod0.xarray.iwrite_5_9)=0.9  V(xmod0.xarray.iwrite_5_10)=0.9  V(xmod0.xarray.iwrite_5_11)=0.9  V(xmod0.xarray.iwrite_5_12)=0.9  V(xmod0.xarray.iwrite_5_13)=0.9  V(xmod0.xarray.iwrite_5_14)=0.9  V(xmod0.xarray.iwrite_5_15)=0.9
.nodeset V(xmod0.xarray.iwrite_6_0)=0.9  V(xmod0.xarray.iwrite_6_1)=0.9  V(xmod0.xarray.iwrite_6_2)=0.9  V(xmod0.xarray.iwrite_6_3)=0.9  V(xmod0.xarray.iwrite_6_4)=0.9  V(xmod0.xarray.iwrite_6_5)=0.9  V(xmod0.xarray.iwrite_6_6)=0.9  V(xmod0.xarray.iwrite_6_7)=0.9  V(xmod0.xarray.iwrite_6_8)=0.9  V(xmod0.xarray.iwrite_6_9)=0.9  V(xmod0.xarray.iwrite_6_10)=0.9  V(xmod0.xarray.iwrite_6_11)=0.9  V(xmod0.xarray.iwrite_6_12)=0.9  V(xmod0.xarray.iwrite_6_13)=0.9  V(xmod0.xarray.iwrite_6_14)=0.9  V(xmod0.xarray.iwrite_6_15)=0.9
.nodeset V(xmod0.xarray.iwrite_7_0)=0.9  V(xmod0.xarray.iwrite_7_1)=0.9  V(xmod0.xarray.iwrite_7_2)=0.9  V(xmod0.xarray.iwrite_7_3)=0.9  V(xmod0.xarray.iwrite_7_4)=0.9  V(xmod0.xarray.iwrite_7_5)=0.9  V(xmod0.xarray.iwrite_7_6)=0.9  V(xmod0.xarray.iwrite_7_7)=0.9  V(xmod0.xarray.iwrite_7_8)=0.9  V(xmod0.xarray.iwrite_7_9)=0.9  V(xmod0.xarray.iwrite_7_10)=0.9  V(xmod0.xarray.iwrite_7_11)=0.9  V(xmod0.xarray.iwrite_7_12)=0.9  V(xmod0.xarray.iwrite_7_13)=0.9  V(xmod0.xarray.iwrite_7_14)=0.9  V(xmod0.xarray.iwrite_7_15)=0.9
.nodeset V(xmod0.xarray.iwrite_8_0)=0.9  V(xmod0.xarray.iwrite_8_1)=0.9  V(xmod0.xarray.iwrite_8_2)=0.9  V(xmod0.xarray.iwrite_8_3)=0.9  V(xmod0.xarray.iwrite_8_4)=0.9  V(xmod0.xarray.iwrite_8_5)=0.9  V(xmod0.xarray.iwrite_8_6)=0.9  V(xmod0.xarray.iwrite_8_7)=0.9  V(xmod0.xarray.iwrite_8_8)=0.9  V(xmod0.xarray.iwrite_8_9)=0.9  V(xmod0.xarray.iwrite_8_10)=0.9  V(xmod0.xarray.iwrite_8_11)=0.9  V(xmod0.xarray.iwrite_8_12)=0.9  V(xmod0.xarray.iwrite_8_13)=0.9  V(xmod0.xarray.iwrite_8_14)=0.9  V(xmod0.xarray.iwrite_8_15)=0.9
.nodeset V(xmod0.xarray.iwrite_9_0)=0.9  V(xmod0.xarray.iwrite_9_1)=0.9  V(xmod0.xarray.iwrite_9_2)=0.9  V(xmod0.xarray.iwrite_9_3)=0.9  V(xmod0.xarray.iwrite_9_4)=0.9  V(xmod0.xarray.iwrite_9_5)=0.9  V(xmod0.xarray.iwrite_9_6)=0.9  V(xmod0.xarray.iwrite_9_7)=0.9  V(xmod0.xarray.iwrite_9_8)=0.9  V(xmod0.xarray.iwrite_9_9)=0.9  V(xmod0.xarray.iwrite_9_10)=0.9  V(xmod0.xarray.iwrite_9_11)=0.9  V(xmod0.xarray.iwrite_9_12)=0.9  V(xmod0.xarray.iwrite_9_13)=0.9  V(xmod0.xarray.iwrite_9_14)=0.9  V(xmod0.xarray.iwrite_9_15)=0.9
.nodeset V(xmod0.xarray.iwrite_10_0)=0.9  V(xmod0.xarray.iwrite_10_1)=0.9  V(xmod0.xarray.iwrite_10_2)=0.9  V(xmod0.xarray.iwrite_10_3)=0.9  V(xmod0.xarray.iwrite_10_4)=0.9  V(xmod0.xarray.iwrite_10_5)=0.9  V(xmod0.xarray.iwrite_10_6)=0.9  V(xmod0.xarray.iwrite_10_7)=0.9  V(xmod0.xarray.iwrite_10_8)=0.9  V(xmod0.xarray.iwrite_10_9)=0.9  V(xmod0.xarray.iwrite_10_10)=0.9  V(xmod0.xarray.iwrite_10_11)=0.9  V(xmod0.xarray.iwrite_10_12)=0.9  V(xmod0.xarray.iwrite_10_13)=0.9  V(xmod0.xarray.iwrite_10_14)=0.9  V(xmod0.xarray.iwrite_10_15)=0.9
.nodeset V(xmod0.xarray.iwrite_11_0)=0.9  V(xmod0.xarray.iwrite_11_1)=0.9  V(xmod0.xarray.iwrite_11_2)=0.9  V(xmod0.xarray.iwrite_11_3)=0.9  V(xmod0.xarray.iwrite_11_4)=0.9  V(xmod0.xarray.iwrite_11_5)=0.9  V(xmod0.xarray.iwrite_11_6)=0.9  V(xmod0.xarray.iwrite_11_7)=0.9  V(xmod0.xarray.iwrite_11_8)=0.9  V(xmod0.xarray.iwrite_11_9)=0.9  V(xmod0.xarray.iwrite_11_10)=0.9  V(xmod0.xarray.iwrite_11_11)=0.9  V(xmod0.xarray.iwrite_11_12)=0.9  V(xmod0.xarray.iwrite_11_13)=0.9  V(xmod0.xarray.iwrite_11_14)=0.9  V(xmod0.xarray.iwrite_11_15)=0.9
.nodeset V(xmod0.xarray.iwrite_12_0)=0.9  V(xmod0.xarray.iwrite_12_1)=0.9  V(xmod0.xarray.iwrite_12_2)=0.9  V(xmod0.xarray.iwrite_12_3)=0.9  V(xmod0.xarray.iwrite_12_4)=0.9  V(xmod0.xarray.iwrite_12_5)=0.9  V(xmod0.xarray.iwrite_12_6)=0.9  V(xmod0.xarray.iwrite_12_7)=0.9  V(xmod0.xarray.iwrite_12_8)=0.9  V(xmod0.xarray.iwrite_12_9)=0.9  V(xmod0.xarray.iwrite_12_10)=0.9  V(xmod0.xarray.iwrite_12_11)=0.9  V(xmod0.xarray.iwrite_12_12)=0.9  V(xmod0.xarray.iwrite_12_13)=0.9  V(xmod0.xarray.iwrite_12_14)=0.9  V(xmod0.xarray.iwrite_12_15)=0.9
.nodeset V(xmod0.xarray.iwrite_13_0)=0.9  V(xmod0.xarray.iwrite_13_1)=0.9  V(xmod0.xarray.iwrite_13_2)=0.9  V(xmod0.xarray.iwrite_13_3)=0.9  V(xmod0.xarray.iwrite_13_4)=0.9  V(xmod0.xarray.iwrite_13_5)=0.9  V(xmod0.xarray.iwrite_13_6)=0.9  V(xmod0.xarray.iwrite_13_7)=0.9  V(xmod0.xarray.iwrite_13_8)=0.9  V(xmod0.xarray.iwrite_13_9)=0.9  V(xmod0.xarray.iwrite_13_10)=0.9  V(xmod0.xarray.iwrite_13_11)=0.9  V(xmod0.xarray.iwrite_13_12)=0.9  V(xmod0.xarray.iwrite_13_13)=0.9  V(xmod0.xarray.iwrite_13_14)=0.9  V(xmod0.xarray.iwrite_13_15)=0.9
.nodeset V(xmod0.xarray.iwrite_14_0)=0.9  V(xmod0.xarray.iwrite_14_1)=0.9  V(xmod0.xarray.iwrite_14_2)=0.9  V(xmod0.xarray.iwrite_14_3)=0.9  V(xmod0.xarray.iwrite_14_4)=0.9  V(xmod0.xarray.iwrite_14_5)=0.9  V(xmod0.xarray.iwrite_14_6)=0.9  V(xmod0.xarray.iwrite_14_7)=0.9  V(xmod0.xarray.iwrite_14_8)=0.9  V(xmod0.xarray.iwrite_14_9)=0.9  V(xmod0.xarray.iwrite_14_10)=0.9  V(xmod0.xarray.iwrite_14_11)=0.9  V(xmod0.xarray.iwrite_14_12)=0.9  V(xmod0.xarray.iwrite_14_13)=0.9  V(xmod0.xarray.iwrite_14_14)=0.9  V(xmod0.xarray.iwrite_14_15)=0.9
.nodeset V(xmod0.xarray.iwrite_15_0)=0.9  V(xmod0.xarray.iwrite_15_1)=0.9  V(xmod0.xarray.iwrite_15_2)=0.9  V(xmod0.xarray.iwrite_15_3)=0.9  V(xmod0.xarray.iwrite_15_4)=0.9  V(xmod0.xarray.iwrite_15_5)=0.9  V(xmod0.xarray.iwrite_15_6)=0.9  V(xmod0.xarray.iwrite_15_7)=0.9  V(xmod0.xarray.iwrite_15_8)=0.9  V(xmod0.xarray.iwrite_15_9)=0.9  V(xmod0.xarray.iwrite_15_10)=0.9  V(xmod0.xarray.iwrite_15_11)=0.9  V(xmod0.xarray.iwrite_15_12)=0.9  V(xmod0.xarray.iwrite_15_13)=0.9  V(xmod0.xarray.iwrite_15_14)=0.9  V(xmod0.xarray.iwrite_15_15)=0.9
.nodeset V(xmod1.xarray.iwrite_0_0)=0.9  V(xmod1.xarray.iwrite_0_1)=0.9  V(xmod1.xarray.iwrite_0_2)=0.9  V(xmod1.xarray.iwrite_0_3)=0.9  V(xmod1.xarray.iwrite_0_4)=0.9  V(xmod1.xarray.iwrite_0_5)=0.9  V(xmod1.xarray.iwrite_0_6)=0.9  V(xmod1.xarray.iwrite_0_7)=0.9  V(xmod1.xarray.iwrite_0_8)=0.9  V(xmod1.xarray.iwrite_0_9)=0.9  V(xmod1.xarray.iwrite_0_10)=0.9  V(xmod1.xarray.iwrite_0_11)=0.9  V(xmod1.xarray.iwrite_0_12)=0.9  V(xmod1.xarray.iwrite_0_13)=0.9  V(xmod1.xarray.iwrite_0_14)=0.9  V(xmod1.xarray.iwrite_0_15)=0.9
.nodeset V(xmod1.xarray.iwrite_1_0)=0.9  V(xmod1.xarray.iwrite_1_1)=0.9  V(xmod1.xarray.iwrite_1_2)=0.9  V(xmod1.xarray.iwrite_1_3)=0.9  V(xmod1.xarray.iwrite_1_4)=0.9  V(xmod1.xarray.iwrite_1_5)=0.9  V(xmod1.xarray.iwrite_1_6)=0.9  V(xmod1.xarray.iwrite_1_7)=0.9  V(xmod1.xarray.iwrite_1_8)=0.9  V(xmod1.xarray.iwrite_1_9)=0.9  V(xmod1.xarray.iwrite_1_10)=0.9  V(xmod1.xarray.iwrite_1_11)=0.9  V(xmod1.xarray.iwrite_1_12)=0.9  V(xmod1.xarray.iwrite_1_13)=0.9  V(xmod1.xarray.iwrite_1_14)=0.9  V(xmod1.xarray.iwrite_1_15)=0.9
.nodeset V(xmod1.xarray.iwrite_2_0)=0.9  V(xmod1.xarray.iwrite_2_1)=0.9  V(xmod1.xarray.iwrite_2_2)=0.9  V(xmod1.xarray.iwrite_2_3)=0.9  V(xmod1.xarray.iwrite_2_4)=0.9  V(xmod1.xarray.iwrite_2_5)=0.9  V(xmod1.xarray.iwrite_2_6)=0.9  V(xmod1.xarray.iwrite_2_7)=0.9  V(xmod1.xarray.iwrite_2_8)=0.9  V(xmod1.xarray.iwrite_2_9)=0.9  V(xmod1.xarray.iwrite_2_10)=0.9  V(xmod1.xarray.iwrite_2_11)=0.9  V(xmod1.xarray.iwrite_2_12)=0.9  V(xmod1.xarray.iwrite_2_13)=0.9  V(xmod1.xarray.iwrite_2_14)=0.9  V(xmod1.xarray.iwrite_2_15)=0.9
.nodeset V(xmod1.xarray.iwrite_3_0)=0.9  V(xmod1.xarray.iwrite_3_1)=0.9  V(xmod1.xarray.iwrite_3_2)=0.9  V(xmod1.xarray.iwrite_3_3)=0.9  V(xmod1.xarray.iwrite_3_4)=0.9  V(xmod1.xarray.iwrite_3_5)=0.9  V(xmod1.xarray.iwrite_3_6)=0.9  V(xmod1.xarray.iwrite_3_7)=0.9  V(xmod1.xarray.iwrite_3_8)=0.9  V(xmod1.xarray.iwrite_3_9)=0.9  V(xmod1.xarray.iwrite_3_10)=0.9  V(xmod1.xarray.iwrite_3_11)=0.9  V(xmod1.xarray.iwrite_3_12)=0.9  V(xmod1.xarray.iwrite_3_13)=0.9  V(xmod1.xarray.iwrite_3_14)=0.9  V(xmod1.xarray.iwrite_3_15)=0.9
.nodeset V(xmod1.xarray.iwrite_4_0)=0.9  V(xmod1.xarray.iwrite_4_1)=0.9  V(xmod1.xarray.iwrite_4_2)=0.9  V(xmod1.xarray.iwrite_4_3)=0.9  V(xmod1.xarray.iwrite_4_4)=0.9  V(xmod1.xarray.iwrite_4_5)=0.9  V(xmod1.xarray.iwrite_4_6)=0.9  V(xmod1.xarray.iwrite_4_7)=0.9  V(xmod1.xarray.iwrite_4_8)=0.9  V(xmod1.xarray.iwrite_4_9)=0.9  V(xmod1.xarray.iwrite_4_10)=0.9  V(xmod1.xarray.iwrite_4_11)=0.9  V(xmod1.xarray.iwrite_4_12)=0.9  V(xmod1.xarray.iwrite_4_13)=0.9  V(xmod1.xarray.iwrite_4_14)=0.9  V(xmod1.xarray.iwrite_4_15)=0.9
.nodeset V(xmod1.xarray.iwrite_5_0)=0.9  V(xmod1.xarray.iwrite_5_1)=0.9  V(xmod1.xarray.iwrite_5_2)=0.9  V(xmod1.xarray.iwrite_5_3)=0.9  V(xmod1.xarray.iwrite_5_4)=0.9  V(xmod1.xarray.iwrite_5_5)=0.9  V(xmod1.xarray.iwrite_5_6)=0.9  V(xmod1.xarray.iwrite_5_7)=0.9  V(xmod1.xarray.iwrite_5_8)=0.9  V(xmod1.xarray.iwrite_5_9)=0.9  V(xmod1.xarray.iwrite_5_10)=0.9  V(xmod1.xarray.iwrite_5_11)=0.9  V(xmod1.xarray.iwrite_5_12)=0.9  V(xmod1.xarray.iwrite_5_13)=0.9  V(xmod1.xarray.iwrite_5_14)=0.9  V(xmod1.xarray.iwrite_5_15)=0.9
.nodeset V(xmod1.xarray.iwrite_6_0)=0.9  V(xmod1.xarray.iwrite_6_1)=0.9  V(xmod1.xarray.iwrite_6_2)=0.9  V(xmod1.xarray.iwrite_6_3)=0.9  V(xmod1.xarray.iwrite_6_4)=0.9  V(xmod1.xarray.iwrite_6_5)=0.9  V(xmod1.xarray.iwrite_6_6)=0.9  V(xmod1.xarray.iwrite_6_7)=0.9  V(xmod1.xarray.iwrite_6_8)=0.9  V(xmod1.xarray.iwrite_6_9)=0.9  V(xmod1.xarray.iwrite_6_10)=0.9  V(xmod1.xarray.iwrite_6_11)=0.9  V(xmod1.xarray.iwrite_6_12)=0.9  V(xmod1.xarray.iwrite_6_13)=0.9  V(xmod1.xarray.iwrite_6_14)=0.9  V(xmod1.xarray.iwrite_6_15)=0.9
.nodeset V(xmod1.xarray.iwrite_7_0)=0.9  V(xmod1.xarray.iwrite_7_1)=0.9  V(xmod1.xarray.iwrite_7_2)=0.9  V(xmod1.xarray.iwrite_7_3)=0.9  V(xmod1.xarray.iwrite_7_4)=0.9  V(xmod1.xarray.iwrite_7_5)=0.9  V(xmod1.xarray.iwrite_7_6)=0.9  V(xmod1.xarray.iwrite_7_7)=0.9  V(xmod1.xarray.iwrite_7_8)=0.9  V(xmod1.xarray.iwrite_7_9)=0.9  V(xmod1.xarray.iwrite_7_10)=0.9  V(xmod1.xarray.iwrite_7_11)=0.9  V(xmod1.xarray.iwrite_7_12)=0.9  V(xmod1.xarray.iwrite_7_13)=0.9  V(xmod1.xarray.iwrite_7_14)=0.9  V(xmod1.xarray.iwrite_7_15)=0.9
.nodeset V(xmod1.xarray.iwrite_8_0)=0.9  V(xmod1.xarray.iwrite_8_1)=0.9  V(xmod1.xarray.iwrite_8_2)=0.9  V(xmod1.xarray.iwrite_8_3)=0.9  V(xmod1.xarray.iwrite_8_4)=0.9  V(xmod1.xarray.iwrite_8_5)=0.9  V(xmod1.xarray.iwrite_8_6)=0.9  V(xmod1.xarray.iwrite_8_7)=0.9  V(xmod1.xarray.iwrite_8_8)=0.9  V(xmod1.xarray.iwrite_8_9)=0.9  V(xmod1.xarray.iwrite_8_10)=0.9  V(xmod1.xarray.iwrite_8_11)=0.9  V(xmod1.xarray.iwrite_8_12)=0.9  V(xmod1.xarray.iwrite_8_13)=0.9  V(xmod1.xarray.iwrite_8_14)=0.9  V(xmod1.xarray.iwrite_8_15)=0.9
.nodeset V(xmod1.xarray.iwrite_9_0)=0.9  V(xmod1.xarray.iwrite_9_1)=0.9  V(xmod1.xarray.iwrite_9_2)=0.9  V(xmod1.xarray.iwrite_9_3)=0.9  V(xmod1.xarray.iwrite_9_4)=0.9  V(xmod1.xarray.iwrite_9_5)=0.9  V(xmod1.xarray.iwrite_9_6)=0.9  V(xmod1.xarray.iwrite_9_7)=0.9  V(xmod1.xarray.iwrite_9_8)=0.9  V(xmod1.xarray.iwrite_9_9)=0.9  V(xmod1.xarray.iwrite_9_10)=0.9  V(xmod1.xarray.iwrite_9_11)=0.9  V(xmod1.xarray.iwrite_9_12)=0.9  V(xmod1.xarray.iwrite_9_13)=0.9  V(xmod1.xarray.iwrite_9_14)=0.9  V(xmod1.xarray.iwrite_9_15)=0.9
.nodeset V(xmod1.xarray.iwrite_10_0)=0.9  V(xmod1.xarray.iwrite_10_1)=0.9  V(xmod1.xarray.iwrite_10_2)=0.9  V(xmod1.xarray.iwrite_10_3)=0.9  V(xmod1.xarray.iwrite_10_4)=0.9  V(xmod1.xarray.iwrite_10_5)=0.9  V(xmod1.xarray.iwrite_10_6)=0.9  V(xmod1.xarray.iwrite_10_7)=0.9  V(xmod1.xarray.iwrite_10_8)=0.9  V(xmod1.xarray.iwrite_10_9)=0.9  V(xmod1.xarray.iwrite_10_10)=0.9  V(xmod1.xarray.iwrite_10_11)=0.9  V(xmod1.xarray.iwrite_10_12)=0.9  V(xmod1.xarray.iwrite_10_13)=0.9  V(xmod1.xarray.iwrite_10_14)=0.9  V(xmod1.xarray.iwrite_10_15)=0.9
.nodeset V(xmod1.xarray.iwrite_11_0)=0.9  V(xmod1.xarray.iwrite_11_1)=0.9  V(xmod1.xarray.iwrite_11_2)=0.9  V(xmod1.xarray.iwrite_11_3)=0.9  V(xmod1.xarray.iwrite_11_4)=0.9  V(xmod1.xarray.iwrite_11_5)=0.9  V(xmod1.xarray.iwrite_11_6)=0.9  V(xmod1.xarray.iwrite_11_7)=0.9  V(xmod1.xarray.iwrite_11_8)=0.9  V(xmod1.xarray.iwrite_11_9)=0.9  V(xmod1.xarray.iwrite_11_10)=0.9  V(xmod1.xarray.iwrite_11_11)=0.9  V(xmod1.xarray.iwrite_11_12)=0.9  V(xmod1.xarray.iwrite_11_13)=0.9  V(xmod1.xarray.iwrite_11_14)=0.9  V(xmod1.xarray.iwrite_11_15)=0.9
.nodeset V(xmod1.xarray.iwrite_12_0)=0.9  V(xmod1.xarray.iwrite_12_1)=0.9  V(xmod1.xarray.iwrite_12_2)=0.9  V(xmod1.xarray.iwrite_12_3)=0.9  V(xmod1.xarray.iwrite_12_4)=0.9  V(xmod1.xarray.iwrite_12_5)=0.9  V(xmod1.xarray.iwrite_12_6)=0.9  V(xmod1.xarray.iwrite_12_7)=0.9  V(xmod1.xarray.iwrite_12_8)=0.9  V(xmod1.xarray.iwrite_12_9)=0.9  V(xmod1.xarray.iwrite_12_10)=0.9  V(xmod1.xarray.iwrite_12_11)=0.9  V(xmod1.xarray.iwrite_12_12)=0.9  V(xmod1.xarray.iwrite_12_13)=0.9  V(xmod1.xarray.iwrite_12_14)=0.9  V(xmod1.xarray.iwrite_12_15)=0.9
.nodeset V(xmod1.xarray.iwrite_13_0)=0.9  V(xmod1.xarray.iwrite_13_1)=0.9  V(xmod1.xarray.iwrite_13_2)=0.9  V(xmod1.xarray.iwrite_13_3)=0.9  V(xmod1.xarray.iwrite_13_4)=0.9  V(xmod1.xarray.iwrite_13_5)=0.9  V(xmod1.xarray.iwrite_13_6)=0.9  V(xmod1.xarray.iwrite_13_7)=0.9  V(xmod1.xarray.iwrite_13_8)=0.9  V(xmod1.xarray.iwrite_13_9)=0.9  V(xmod1.xarray.iwrite_13_10)=0.9  V(xmod1.xarray.iwrite_13_11)=0.9  V(xmod1.xarray.iwrite_13_12)=0.9  V(xmod1.xarray.iwrite_13_13)=0.9  V(xmod1.xarray.iwrite_13_14)=0.9  V(xmod1.xarray.iwrite_13_15)=0.9
.nodeset V(xmod1.xarray.iwrite_14_0)=0.9  V(xmod1.xarray.iwrite_14_1)=0.9  V(xmod1.xarray.iwrite_14_2)=0.9  V(xmod1.xarray.iwrite_14_3)=0.9  V(xmod1.xarray.iwrite_14_4)=0.9  V(xmod1.xarray.iwrite_14_5)=0.9  V(xmod1.xarray.iwrite_14_6)=0.9  V(xmod1.xarray.iwrite_14_7)=0.9  V(xmod1.xarray.iwrite_14_8)=0.9  V(xmod1.xarray.iwrite_14_9)=0.9  V(xmod1.xarray.iwrite_14_10)=0.9  V(xmod1.xarray.iwrite_14_11)=0.9  V(xmod1.xarray.iwrite_14_12)=0.9  V(xmod1.xarray.iwrite_14_13)=0.9  V(xmod1.xarray.iwrite_14_14)=0.9  V(xmod1.xarray.iwrite_14_15)=0.9
.nodeset V(xmod1.xarray.iwrite_15_0)=0.9  V(xmod1.xarray.iwrite_15_1)=0.9  V(xmod1.xarray.iwrite_15_2)=0.9  V(xmod1.xarray.iwrite_15_3)=0.9  V(xmod1.xarray.iwrite_15_4)=0.9  V(xmod1.xarray.iwrite_15_5)=0.9  V(xmod1.xarray.iwrite_15_6)=0.9  V(xmod1.xarray.iwrite_15_7)=0.9  V(xmod1.xarray.iwrite_15_8)=0.9  V(xmod1.xarray.iwrite_15_9)=0.9  V(xmod1.xarray.iwrite_15_10)=0.9  V(xmod1.xarray.iwrite_15_11)=0.9  V(xmod1.xarray.iwrite_15_12)=0.9  V(xmod1.xarray.iwrite_15_13)=0.9  V(xmod1.xarray.iwrite_15_14)=0.9  V(xmod1.xarray.iwrite_15_15)=0.9
.nodeset V(xmod2.xarray.iwrite_0_0)=0.9  V(xmod2.xarray.iwrite_0_1)=0.9  V(xmod2.xarray.iwrite_0_2)=0.9  V(xmod2.xarray.iwrite_0_3)=0.9  V(xmod2.xarray.iwrite_0_4)=0.9  V(xmod2.xarray.iwrite_0_5)=0.9  V(xmod2.xarray.iwrite_0_6)=0.9  V(xmod2.xarray.iwrite_0_7)=0.9  V(xmod2.xarray.iwrite_0_8)=0.9  V(xmod2.xarray.iwrite_0_9)=0.9  V(xmod2.xarray.iwrite_0_10)=0.9  V(xmod2.xarray.iwrite_0_11)=0.9  V(xmod2.xarray.iwrite_0_12)=0.9  V(xmod2.xarray.iwrite_0_13)=0.9  V(xmod2.xarray.iwrite_0_14)=0.9  V(xmod2.xarray.iwrite_0_15)=0.9
.nodeset V(xmod2.xarray.iwrite_1_0)=0.9  V(xmod2.xarray.iwrite_1_1)=0.9  V(xmod2.xarray.iwrite_1_2)=0.9  V(xmod2.xarray.iwrite_1_3)=0.9  V(xmod2.xarray.iwrite_1_4)=0.9  V(xmod2.xarray.iwrite_1_5)=0.9  V(xmod2.xarray.iwrite_1_6)=0.9  V(xmod2.xarray.iwrite_1_7)=0.9  V(xmod2.xarray.iwrite_1_8)=0.9  V(xmod2.xarray.iwrite_1_9)=0.9  V(xmod2.xarray.iwrite_1_10)=0.9  V(xmod2.xarray.iwrite_1_11)=0.9  V(xmod2.xarray.iwrite_1_12)=0.9  V(xmod2.xarray.iwrite_1_13)=0.9  V(xmod2.xarray.iwrite_1_14)=0.9  V(xmod2.xarray.iwrite_1_15)=0.9
.nodeset V(xmod2.xarray.iwrite_2_0)=0.9  V(xmod2.xarray.iwrite_2_1)=0.9  V(xmod2.xarray.iwrite_2_2)=0.9  V(xmod2.xarray.iwrite_2_3)=0.9  V(xmod2.xarray.iwrite_2_4)=0.9  V(xmod2.xarray.iwrite_2_5)=0.9  V(xmod2.xarray.iwrite_2_6)=0.9  V(xmod2.xarray.iwrite_2_7)=0.9  V(xmod2.xarray.iwrite_2_8)=0.9  V(xmod2.xarray.iwrite_2_9)=0.9  V(xmod2.xarray.iwrite_2_10)=0.9  V(xmod2.xarray.iwrite_2_11)=0.9  V(xmod2.xarray.iwrite_2_12)=0.9  V(xmod2.xarray.iwrite_2_13)=0.9  V(xmod2.xarray.iwrite_2_14)=0.9  V(xmod2.xarray.iwrite_2_15)=0.9
.nodeset V(xmod2.xarray.iwrite_3_0)=0.9  V(xmod2.xarray.iwrite_3_1)=0.9  V(xmod2.xarray.iwrite_3_2)=0.9  V(xmod2.xarray.iwrite_3_3)=0.9  V(xmod2.xarray.iwrite_3_4)=0.9  V(xmod2.xarray.iwrite_3_5)=0.9  V(xmod2.xarray.iwrite_3_6)=0.9  V(xmod2.xarray.iwrite_3_7)=0.9  V(xmod2.xarray.iwrite_3_8)=0.9  V(xmod2.xarray.iwrite_3_9)=0.9  V(xmod2.xarray.iwrite_3_10)=0.9  V(xmod2.xarray.iwrite_3_11)=0.9  V(xmod2.xarray.iwrite_3_12)=0.9  V(xmod2.xarray.iwrite_3_13)=0.9  V(xmod2.xarray.iwrite_3_14)=0.9  V(xmod2.xarray.iwrite_3_15)=0.9
.nodeset V(xmod2.xarray.iwrite_4_0)=0.9  V(xmod2.xarray.iwrite_4_1)=0.9  V(xmod2.xarray.iwrite_4_2)=0.9  V(xmod2.xarray.iwrite_4_3)=0.9  V(xmod2.xarray.iwrite_4_4)=0.9  V(xmod2.xarray.iwrite_4_5)=0.9  V(xmod2.xarray.iwrite_4_6)=0.9  V(xmod2.xarray.iwrite_4_7)=0.9  V(xmod2.xarray.iwrite_4_8)=0.9  V(xmod2.xarray.iwrite_4_9)=0.9  V(xmod2.xarray.iwrite_4_10)=0.9  V(xmod2.xarray.iwrite_4_11)=0.9  V(xmod2.xarray.iwrite_4_12)=0.9  V(xmod2.xarray.iwrite_4_13)=0.9  V(xmod2.xarray.iwrite_4_14)=0.9  V(xmod2.xarray.iwrite_4_15)=0.9
.nodeset V(xmod2.xarray.iwrite_5_0)=0.9  V(xmod2.xarray.iwrite_5_1)=0.9  V(xmod2.xarray.iwrite_5_2)=0.9  V(xmod2.xarray.iwrite_5_3)=0.9  V(xmod2.xarray.iwrite_5_4)=0.9  V(xmod2.xarray.iwrite_5_5)=0.9  V(xmod2.xarray.iwrite_5_6)=0.9  V(xmod2.xarray.iwrite_5_7)=0.9  V(xmod2.xarray.iwrite_5_8)=0.9  V(xmod2.xarray.iwrite_5_9)=0.9  V(xmod2.xarray.iwrite_5_10)=0.9  V(xmod2.xarray.iwrite_5_11)=0.9  V(xmod2.xarray.iwrite_5_12)=0.9  V(xmod2.xarray.iwrite_5_13)=0.9  V(xmod2.xarray.iwrite_5_14)=0.9  V(xmod2.xarray.iwrite_5_15)=0.9
.nodeset V(xmod2.xarray.iwrite_6_0)=0.9  V(xmod2.xarray.iwrite_6_1)=0.9  V(xmod2.xarray.iwrite_6_2)=0.9  V(xmod2.xarray.iwrite_6_3)=0.9  V(xmod2.xarray.iwrite_6_4)=0.9  V(xmod2.xarray.iwrite_6_5)=0.9  V(xmod2.xarray.iwrite_6_6)=0.9  V(xmod2.xarray.iwrite_6_7)=0.9  V(xmod2.xarray.iwrite_6_8)=0.9  V(xmod2.xarray.iwrite_6_9)=0.9  V(xmod2.xarray.iwrite_6_10)=0.9  V(xmod2.xarray.iwrite_6_11)=0.9  V(xmod2.xarray.iwrite_6_12)=0.9  V(xmod2.xarray.iwrite_6_13)=0.9  V(xmod2.xarray.iwrite_6_14)=0.9  V(xmod2.xarray.iwrite_6_15)=0.9
.nodeset V(xmod2.xarray.iwrite_7_0)=0.9  V(xmod2.xarray.iwrite_7_1)=0.9  V(xmod2.xarray.iwrite_7_2)=0.9  V(xmod2.xarray.iwrite_7_3)=0.9  V(xmod2.xarray.iwrite_7_4)=0.9  V(xmod2.xarray.iwrite_7_5)=0.9  V(xmod2.xarray.iwrite_7_6)=0.9  V(xmod2.xarray.iwrite_7_7)=0.9  V(xmod2.xarray.iwrite_7_8)=0.9  V(xmod2.xarray.iwrite_7_9)=0.9  V(xmod2.xarray.iwrite_7_10)=0.9  V(xmod2.xarray.iwrite_7_11)=0.9  V(xmod2.xarray.iwrite_7_12)=0.9  V(xmod2.xarray.iwrite_7_13)=0.9  V(xmod2.xarray.iwrite_7_14)=0.9  V(xmod2.xarray.iwrite_7_15)=0.9
.nodeset V(xmod2.xarray.iwrite_8_0)=0.9  V(xmod2.xarray.iwrite_8_1)=0.9  V(xmod2.xarray.iwrite_8_2)=0.9  V(xmod2.xarray.iwrite_8_3)=0.9  V(xmod2.xarray.iwrite_8_4)=0.9  V(xmod2.xarray.iwrite_8_5)=0.9  V(xmod2.xarray.iwrite_8_6)=0.9  V(xmod2.xarray.iwrite_8_7)=0.9  V(xmod2.xarray.iwrite_8_8)=0.9  V(xmod2.xarray.iwrite_8_9)=0.9  V(xmod2.xarray.iwrite_8_10)=0.9  V(xmod2.xarray.iwrite_8_11)=0.9  V(xmod2.xarray.iwrite_8_12)=0.9  V(xmod2.xarray.iwrite_8_13)=0.9  V(xmod2.xarray.iwrite_8_14)=0.9  V(xmod2.xarray.iwrite_8_15)=0.9
.nodeset V(xmod2.xarray.iwrite_9_0)=0.9  V(xmod2.xarray.iwrite_9_1)=0.9  V(xmod2.xarray.iwrite_9_2)=0.9  V(xmod2.xarray.iwrite_9_3)=0.9  V(xmod2.xarray.iwrite_9_4)=0.9  V(xmod2.xarray.iwrite_9_5)=0.9  V(xmod2.xarray.iwrite_9_6)=0.9  V(xmod2.xarray.iwrite_9_7)=0.9  V(xmod2.xarray.iwrite_9_8)=0.9  V(xmod2.xarray.iwrite_9_9)=0.9  V(xmod2.xarray.iwrite_9_10)=0.9  V(xmod2.xarray.iwrite_9_11)=0.9  V(xmod2.xarray.iwrite_9_12)=0.9  V(xmod2.xarray.iwrite_9_13)=0.9  V(xmod2.xarray.iwrite_9_14)=0.9  V(xmod2.xarray.iwrite_9_15)=0.9
.nodeset V(xmod2.xarray.iwrite_10_0)=0.9  V(xmod2.xarray.iwrite_10_1)=0.9  V(xmod2.xarray.iwrite_10_2)=0.9  V(xmod2.xarray.iwrite_10_3)=0.9  V(xmod2.xarray.iwrite_10_4)=0.9  V(xmod2.xarray.iwrite_10_5)=0.9  V(xmod2.xarray.iwrite_10_6)=0.9  V(xmod2.xarray.iwrite_10_7)=0.9  V(xmod2.xarray.iwrite_10_8)=0.9  V(xmod2.xarray.iwrite_10_9)=0.9  V(xmod2.xarray.iwrite_10_10)=0.9  V(xmod2.xarray.iwrite_10_11)=0.9  V(xmod2.xarray.iwrite_10_12)=0.9  V(xmod2.xarray.iwrite_10_13)=0.9  V(xmod2.xarray.iwrite_10_14)=0.9  V(xmod2.xarray.iwrite_10_15)=0.9
.nodeset V(xmod2.xarray.iwrite_11_0)=0.9  V(xmod2.xarray.iwrite_11_1)=0.9  V(xmod2.xarray.iwrite_11_2)=0.9  V(xmod2.xarray.iwrite_11_3)=0.9  V(xmod2.xarray.iwrite_11_4)=0.9  V(xmod2.xarray.iwrite_11_5)=0.9  V(xmod2.xarray.iwrite_11_6)=0.9  V(xmod2.xarray.iwrite_11_7)=0.9  V(xmod2.xarray.iwrite_11_8)=0.9  V(xmod2.xarray.iwrite_11_9)=0.9  V(xmod2.xarray.iwrite_11_10)=0.9  V(xmod2.xarray.iwrite_11_11)=0.9  V(xmod2.xarray.iwrite_11_12)=0.9  V(xmod2.xarray.iwrite_11_13)=0.9  V(xmod2.xarray.iwrite_11_14)=0.9  V(xmod2.xarray.iwrite_11_15)=0.9
.nodeset V(xmod2.xarray.iwrite_12_0)=0.9  V(xmod2.xarray.iwrite_12_1)=0.9  V(xmod2.xarray.iwrite_12_2)=0.9  V(xmod2.xarray.iwrite_12_3)=0.9  V(xmod2.xarray.iwrite_12_4)=0.9  V(xmod2.xarray.iwrite_12_5)=0.9  V(xmod2.xarray.iwrite_12_6)=0.9  V(xmod2.xarray.iwrite_12_7)=0.9  V(xmod2.xarray.iwrite_12_8)=0.9  V(xmod2.xarray.iwrite_12_9)=0.9  V(xmod2.xarray.iwrite_12_10)=0.9  V(xmod2.xarray.iwrite_12_11)=0.9  V(xmod2.xarray.iwrite_12_12)=0.9  V(xmod2.xarray.iwrite_12_13)=0.9  V(xmod2.xarray.iwrite_12_14)=0.9  V(xmod2.xarray.iwrite_12_15)=0.9
.nodeset V(xmod2.xarray.iwrite_13_0)=0.9  V(xmod2.xarray.iwrite_13_1)=0.9  V(xmod2.xarray.iwrite_13_2)=0.9  V(xmod2.xarray.iwrite_13_3)=0.9  V(xmod2.xarray.iwrite_13_4)=0.9  V(xmod2.xarray.iwrite_13_5)=0.9  V(xmod2.xarray.iwrite_13_6)=0.9  V(xmod2.xarray.iwrite_13_7)=0.9  V(xmod2.xarray.iwrite_13_8)=0.9  V(xmod2.xarray.iwrite_13_9)=0.9  V(xmod2.xarray.iwrite_13_10)=0.9  V(xmod2.xarray.iwrite_13_11)=0.9  V(xmod2.xarray.iwrite_13_12)=0.9  V(xmod2.xarray.iwrite_13_13)=0.9  V(xmod2.xarray.iwrite_13_14)=0.9  V(xmod2.xarray.iwrite_13_15)=0.9
.nodeset V(xmod2.xarray.iwrite_14_0)=0.9  V(xmod2.xarray.iwrite_14_1)=0.9  V(xmod2.xarray.iwrite_14_2)=0.9  V(xmod2.xarray.iwrite_14_3)=0.9  V(xmod2.xarray.iwrite_14_4)=0.9  V(xmod2.xarray.iwrite_14_5)=0.9  V(xmod2.xarray.iwrite_14_6)=0.9  V(xmod2.xarray.iwrite_14_7)=0.9  V(xmod2.xarray.iwrite_14_8)=0.9  V(xmod2.xarray.iwrite_14_9)=0.9  V(xmod2.xarray.iwrite_14_10)=0.9  V(xmod2.xarray.iwrite_14_11)=0.9  V(xmod2.xarray.iwrite_14_12)=0.9  V(xmod2.xarray.iwrite_14_13)=0.9  V(xmod2.xarray.iwrite_14_14)=0.9  V(xmod2.xarray.iwrite_14_15)=0.9
.nodeset V(xmod2.xarray.iwrite_15_0)=0.9  V(xmod2.xarray.iwrite_15_1)=0.9  V(xmod2.xarray.iwrite_15_2)=0.9  V(xmod2.xarray.iwrite_15_3)=0.9  V(xmod2.xarray.iwrite_15_4)=0.9  V(xmod2.xarray.iwrite_15_5)=0.9  V(xmod2.xarray.iwrite_15_6)=0.9  V(xmod2.xarray.iwrite_15_7)=0.9  V(xmod2.xarray.iwrite_15_8)=0.9  V(xmod2.xarray.iwrite_15_9)=0.9  V(xmod2.xarray.iwrite_15_10)=0.9  V(xmod2.xarray.iwrite_15_11)=0.9  V(xmod2.xarray.iwrite_15_12)=0.9  V(xmod2.xarray.iwrite_15_13)=0.9  V(xmod2.xarray.iwrite_15_14)=0.9  V(xmod2.xarray.iwrite_15_15)=0.9
.nodeset V(xmod3.xarray.iwrite_0_0)=0.9  V(xmod3.xarray.iwrite_0_1)=0.9  V(xmod3.xarray.iwrite_0_2)=0.9  V(xmod3.xarray.iwrite_0_3)=0.9  V(xmod3.xarray.iwrite_0_4)=0.9  V(xmod3.xarray.iwrite_0_5)=0.9  V(xmod3.xarray.iwrite_0_6)=0.9  V(xmod3.xarray.iwrite_0_7)=0.9  V(xmod3.xarray.iwrite_0_8)=0.9  V(xmod3.xarray.iwrite_0_9)=0.9  V(xmod3.xarray.iwrite_0_10)=0.9  V(xmod3.xarray.iwrite_0_11)=0.9  V(xmod3.xarray.iwrite_0_12)=0.9  V(xmod3.xarray.iwrite_0_13)=0.9  V(xmod3.xarray.iwrite_0_14)=0.9  V(xmod3.xarray.iwrite_0_15)=0.9
.nodeset V(xmod3.xarray.iwrite_1_0)=0.9  V(xmod3.xarray.iwrite_1_1)=0.9  V(xmod3.xarray.iwrite_1_2)=0.9  V(xmod3.xarray.iwrite_1_3)=0.9  V(xmod3.xarray.iwrite_1_4)=0.9  V(xmod3.xarray.iwrite_1_5)=0.9  V(xmod3.xarray.iwrite_1_6)=0.9  V(xmod3.xarray.iwrite_1_7)=0.9  V(xmod3.xarray.iwrite_1_8)=0.9  V(xmod3.xarray.iwrite_1_9)=0.9  V(xmod3.xarray.iwrite_1_10)=0.9  V(xmod3.xarray.iwrite_1_11)=0.9  V(xmod3.xarray.iwrite_1_12)=0.9  V(xmod3.xarray.iwrite_1_13)=0.9  V(xmod3.xarray.iwrite_1_14)=0.9  V(xmod3.xarray.iwrite_1_15)=0.9
.nodeset V(xmod3.xarray.iwrite_2_0)=0.9  V(xmod3.xarray.iwrite_2_1)=0.9  V(xmod3.xarray.iwrite_2_2)=0.9  V(xmod3.xarray.iwrite_2_3)=0.9  V(xmod3.xarray.iwrite_2_4)=0.9  V(xmod3.xarray.iwrite_2_5)=0.9  V(xmod3.xarray.iwrite_2_6)=0.9  V(xmod3.xarray.iwrite_2_7)=0.9  V(xmod3.xarray.iwrite_2_8)=0.9  V(xmod3.xarray.iwrite_2_9)=0.9  V(xmod3.xarray.iwrite_2_10)=0.9  V(xmod3.xarray.iwrite_2_11)=0.9  V(xmod3.xarray.iwrite_2_12)=0.9  V(xmod3.xarray.iwrite_2_13)=0.9  V(xmod3.xarray.iwrite_2_14)=0.9  V(xmod3.xarray.iwrite_2_15)=0.9
.nodeset V(xmod3.xarray.iwrite_3_0)=0.9  V(xmod3.xarray.iwrite_3_1)=0.9  V(xmod3.xarray.iwrite_3_2)=0.9  V(xmod3.xarray.iwrite_3_3)=0.9  V(xmod3.xarray.iwrite_3_4)=0.9  V(xmod3.xarray.iwrite_3_5)=0.9  V(xmod3.xarray.iwrite_3_6)=0.9  V(xmod3.xarray.iwrite_3_7)=0.9  V(xmod3.xarray.iwrite_3_8)=0.9  V(xmod3.xarray.iwrite_3_9)=0.9  V(xmod3.xarray.iwrite_3_10)=0.9  V(xmod3.xarray.iwrite_3_11)=0.9  V(xmod3.xarray.iwrite_3_12)=0.9  V(xmod3.xarray.iwrite_3_13)=0.9  V(xmod3.xarray.iwrite_3_14)=0.9  V(xmod3.xarray.iwrite_3_15)=0.9
.nodeset V(xmod3.xarray.iwrite_4_0)=0.9  V(xmod3.xarray.iwrite_4_1)=0.9  V(xmod3.xarray.iwrite_4_2)=0.9  V(xmod3.xarray.iwrite_4_3)=0.9  V(xmod3.xarray.iwrite_4_4)=0.9  V(xmod3.xarray.iwrite_4_5)=0.9  V(xmod3.xarray.iwrite_4_6)=0.9  V(xmod3.xarray.iwrite_4_7)=0.9  V(xmod3.xarray.iwrite_4_8)=0.9  V(xmod3.xarray.iwrite_4_9)=0.9  V(xmod3.xarray.iwrite_4_10)=0.9  V(xmod3.xarray.iwrite_4_11)=0.9  V(xmod3.xarray.iwrite_4_12)=0.9  V(xmod3.xarray.iwrite_4_13)=0.9  V(xmod3.xarray.iwrite_4_14)=0.9  V(xmod3.xarray.iwrite_4_15)=0.9
.nodeset V(xmod3.xarray.iwrite_5_0)=0.9  V(xmod3.xarray.iwrite_5_1)=0.9  V(xmod3.xarray.iwrite_5_2)=0.9  V(xmod3.xarray.iwrite_5_3)=0.9  V(xmod3.xarray.iwrite_5_4)=0.9  V(xmod3.xarray.iwrite_5_5)=0.9  V(xmod3.xarray.iwrite_5_6)=0.9  V(xmod3.xarray.iwrite_5_7)=0.9  V(xmod3.xarray.iwrite_5_8)=0.9  V(xmod3.xarray.iwrite_5_9)=0.9  V(xmod3.xarray.iwrite_5_10)=0.9  V(xmod3.xarray.iwrite_5_11)=0.9  V(xmod3.xarray.iwrite_5_12)=0.9  V(xmod3.xarray.iwrite_5_13)=0.9  V(xmod3.xarray.iwrite_5_14)=0.9  V(xmod3.xarray.iwrite_5_15)=0.9
.nodeset V(xmod3.xarray.iwrite_6_0)=0.9  V(xmod3.xarray.iwrite_6_1)=0.9  V(xmod3.xarray.iwrite_6_2)=0.9  V(xmod3.xarray.iwrite_6_3)=0.9  V(xmod3.xarray.iwrite_6_4)=0.9  V(xmod3.xarray.iwrite_6_5)=0.9  V(xmod3.xarray.iwrite_6_6)=0.9  V(xmod3.xarray.iwrite_6_7)=0.9  V(xmod3.xarray.iwrite_6_8)=0.9  V(xmod3.xarray.iwrite_6_9)=0.9  V(xmod3.xarray.iwrite_6_10)=0.9  V(xmod3.xarray.iwrite_6_11)=0.9  V(xmod3.xarray.iwrite_6_12)=0.9  V(xmod3.xarray.iwrite_6_13)=0.9  V(xmod3.xarray.iwrite_6_14)=0.9  V(xmod3.xarray.iwrite_6_15)=0.9
.nodeset V(xmod3.xarray.iwrite_7_0)=0.9  V(xmod3.xarray.iwrite_7_1)=0.9  V(xmod3.xarray.iwrite_7_2)=0.9  V(xmod3.xarray.iwrite_7_3)=0.9  V(xmod3.xarray.iwrite_7_4)=0.9  V(xmod3.xarray.iwrite_7_5)=0.9  V(xmod3.xarray.iwrite_7_6)=0.9  V(xmod3.xarray.iwrite_7_7)=0.9  V(xmod3.xarray.iwrite_7_8)=0.9  V(xmod3.xarray.iwrite_7_9)=0.9  V(xmod3.xarray.iwrite_7_10)=0.9  V(xmod3.xarray.iwrite_7_11)=0.9  V(xmod3.xarray.iwrite_7_12)=0.9  V(xmod3.xarray.iwrite_7_13)=0.9  V(xmod3.xarray.iwrite_7_14)=0.9  V(xmod3.xarray.iwrite_7_15)=0.9
.nodeset V(xmod3.xarray.iwrite_8_0)=0.9  V(xmod3.xarray.iwrite_8_1)=0.9  V(xmod3.xarray.iwrite_8_2)=0.9  V(xmod3.xarray.iwrite_8_3)=0.9  V(xmod3.xarray.iwrite_8_4)=0.9  V(xmod3.xarray.iwrite_8_5)=0.9  V(xmod3.xarray.iwrite_8_6)=0.9  V(xmod3.xarray.iwrite_8_7)=0.9  V(xmod3.xarray.iwrite_8_8)=0.9  V(xmod3.xarray.iwrite_8_9)=0.9  V(xmod3.xarray.iwrite_8_10)=0.9  V(xmod3.xarray.iwrite_8_11)=0.9  V(xmod3.xarray.iwrite_8_12)=0.9  V(xmod3.xarray.iwrite_8_13)=0.9  V(xmod3.xarray.iwrite_8_14)=0.9  V(xmod3.xarray.iwrite_8_15)=0.9
.nodeset V(xmod3.xarray.iwrite_9_0)=0.9  V(xmod3.xarray.iwrite_9_1)=0.9  V(xmod3.xarray.iwrite_9_2)=0.9  V(xmod3.xarray.iwrite_9_3)=0.9  V(xmod3.xarray.iwrite_9_4)=0.9  V(xmod3.xarray.iwrite_9_5)=0.9  V(xmod3.xarray.iwrite_9_6)=0.9  V(xmod3.xarray.iwrite_9_7)=0.9  V(xmod3.xarray.iwrite_9_8)=0.9  V(xmod3.xarray.iwrite_9_9)=0.9  V(xmod3.xarray.iwrite_9_10)=0.9  V(xmod3.xarray.iwrite_9_11)=0.9  V(xmod3.xarray.iwrite_9_12)=0.9  V(xmod3.xarray.iwrite_9_13)=0.9  V(xmod3.xarray.iwrite_9_14)=0.9  V(xmod3.xarray.iwrite_9_15)=0.9
.nodeset V(xmod3.xarray.iwrite_10_0)=0.9  V(xmod3.xarray.iwrite_10_1)=0.9  V(xmod3.xarray.iwrite_10_2)=0.9  V(xmod3.xarray.iwrite_10_3)=0.9  V(xmod3.xarray.iwrite_10_4)=0.9  V(xmod3.xarray.iwrite_10_5)=0.9  V(xmod3.xarray.iwrite_10_6)=0.9  V(xmod3.xarray.iwrite_10_7)=0.9  V(xmod3.xarray.iwrite_10_8)=0.9  V(xmod3.xarray.iwrite_10_9)=0.9  V(xmod3.xarray.iwrite_10_10)=0.9  V(xmod3.xarray.iwrite_10_11)=0.9  V(xmod3.xarray.iwrite_10_12)=0.9  V(xmod3.xarray.iwrite_10_13)=0.9  V(xmod3.xarray.iwrite_10_14)=0.9  V(xmod3.xarray.iwrite_10_15)=0.9
.nodeset V(xmod3.xarray.iwrite_11_0)=0.9  V(xmod3.xarray.iwrite_11_1)=0.9  V(xmod3.xarray.iwrite_11_2)=0.9  V(xmod3.xarray.iwrite_11_3)=0.9  V(xmod3.xarray.iwrite_11_4)=0.9  V(xmod3.xarray.iwrite_11_5)=0.9  V(xmod3.xarray.iwrite_11_6)=0.9  V(xmod3.xarray.iwrite_11_7)=0.9  V(xmod3.xarray.iwrite_11_8)=0.9  V(xmod3.xarray.iwrite_11_9)=0.9  V(xmod3.xarray.iwrite_11_10)=0.9  V(xmod3.xarray.iwrite_11_11)=0.9  V(xmod3.xarray.iwrite_11_12)=0.9  V(xmod3.xarray.iwrite_11_13)=0.9  V(xmod3.xarray.iwrite_11_14)=0.9  V(xmod3.xarray.iwrite_11_15)=0.9
.nodeset V(xmod3.xarray.iwrite_12_0)=0.9  V(xmod3.xarray.iwrite_12_1)=0.9  V(xmod3.xarray.iwrite_12_2)=0.9  V(xmod3.xarray.iwrite_12_3)=0.9  V(xmod3.xarray.iwrite_12_4)=0.9  V(xmod3.xarray.iwrite_12_5)=0.9  V(xmod3.xarray.iwrite_12_6)=0.9  V(xmod3.xarray.iwrite_12_7)=0.9  V(xmod3.xarray.iwrite_12_8)=0.9  V(xmod3.xarray.iwrite_12_9)=0.9  V(xmod3.xarray.iwrite_12_10)=0.9  V(xmod3.xarray.iwrite_12_11)=0.9  V(xmod3.xarray.iwrite_12_12)=0.9  V(xmod3.xarray.iwrite_12_13)=0.9  V(xmod3.xarray.iwrite_12_14)=0.9  V(xmod3.xarray.iwrite_12_15)=0.9
.nodeset V(xmod3.xarray.iwrite_13_0)=0.9  V(xmod3.xarray.iwrite_13_1)=0.9  V(xmod3.xarray.iwrite_13_2)=0.9  V(xmod3.xarray.iwrite_13_3)=0.9  V(xmod3.xarray.iwrite_13_4)=0.9  V(xmod3.xarray.iwrite_13_5)=0.9  V(xmod3.xarray.iwrite_13_6)=0.9  V(xmod3.xarray.iwrite_13_7)=0.9  V(xmod3.xarray.iwrite_13_8)=0.9  V(xmod3.xarray.iwrite_13_9)=0.9  V(xmod3.xarray.iwrite_13_10)=0.9  V(xmod3.xarray.iwrite_13_11)=0.9  V(xmod3.xarray.iwrite_13_12)=0.9  V(xmod3.xarray.iwrite_13_13)=0.9  V(xmod3.xarray.iwrite_13_14)=0.9  V(xmod3.xarray.iwrite_13_15)=0.9
.nodeset V(xmod3.xarray.iwrite_14_0)=0.9  V(xmod3.xarray.iwrite_14_1)=0.9  V(xmod3.xarray.iwrite_14_2)=0.9  V(xmod3.xarray.iwrite_14_3)=0.9  V(xmod3.xarray.iwrite_14_4)=0.9  V(xmod3.xarray.iwrite_14_5)=0.9  V(xmod3.xarray.iwrite_14_6)=0.9  V(xmod3.xarray.iwrite_14_7)=0.9  V(xmod3.xarray.iwrite_14_8)=0.9  V(xmod3.xarray.iwrite_14_9)=0.9  V(xmod3.xarray.iwrite_14_10)=0.9  V(xmod3.xarray.iwrite_14_11)=0.9  V(xmod3.xarray.iwrite_14_12)=0.9  V(xmod3.xarray.iwrite_14_13)=0.9  V(xmod3.xarray.iwrite_14_14)=0.9  V(xmod3.xarray.iwrite_14_15)=0.9
.nodeset V(xmod3.xarray.iwrite_15_0)=0.9  V(xmod3.xarray.iwrite_15_1)=0.9  V(xmod3.xarray.iwrite_15_2)=0.9  V(xmod3.xarray.iwrite_15_3)=0.9  V(xmod3.xarray.iwrite_15_4)=0.9  V(xmod3.xarray.iwrite_15_5)=0.9  V(xmod3.xarray.iwrite_15_6)=0.9  V(xmod3.xarray.iwrite_15_7)=0.9  V(xmod3.xarray.iwrite_15_8)=0.9  V(xmod3.xarray.iwrite_15_9)=0.9  V(xmod3.xarray.iwrite_15_10)=0.9  V(xmod3.xarray.iwrite_15_11)=0.9  V(xmod3.xarray.iwrite_15_12)=0.9  V(xmod3.xarray.iwrite_15_13)=0.9  V(xmod3.xarray.iwrite_15_14)=0.9  V(xmod3.xarray.iwrite_15_15)=0.9

* =============================================================================
.control

  set filetype = ascii

  * ──────────────────────────────────────────────────────────────────────────
  * T1: Operating point — all inputs at Vcm, all WE=0
  * ──────────────────────────────────────────────────────────────────────────
  echo ""
  echo "======================================================"
  echo " T1: 4-layer operating point"
  echo "======================================================"

  op

  * Bias rails
  echo "  --- Bias rails ---"
  echo "  V(vbias_n)       = " $&V(vbias_n)       "  (target: 0.760)"
  echo "  V(vcm)           = " $&V(vcm)           "  (target: 0.900)"
  echo "  V(vpi)           = " $&V(vpi)           "  (target: 0.650)"
  echo "  V(ncm_iout)      = " $&V(ncm_iout)      "  (balanced iout OP stiff; target 0.468)"
  echo "  V(vcm_upper_01)  = " $&V(vcm_upper_01) "  (PMOS SF ref out; target ≈1.14)"
  echo "  V(vcm_upper_12)  = " $&V(vcm_upper_12) "  (PMOS SF ref out; target ≈1.14)"
  echo "  V(vcm_upper_23)  = " $&V(vcm_upper_23) "  (PMOS SF ref out; target ≈1.14)"
  echo ""

  * Ascending signal path (row 0)
  echo "  --- Ascending signal path (row 0) ---"
  echo "  V(m0_iout_0)  = " $&V(m0_iout_0)  "  (mod0 KCL bus; target ≈0.468)"
  echo "  V(m1_inp_0)   = " $&V(m1_inp_0)   "  (PMOS SF out → mod1 col; target ≈1.14)"
  echo "  V(m1_iout_0)  = " $&V(m1_iout_0)  "  (mod1 KCL bus; target ≈0.468 after §72 fix)"
  echo "  V(m2_inp_0)   = " $&V(m2_inp_0)   "  (PMOS SF out → mod2 col)"
  echo "  V(m2_iout_0)  = " $&V(m2_iout_0)  "  (mod2 KCL bus)"
  echo "  V(m3_inp_0)   = " $&V(m3_inp_0)   "  (PMOS SF out → mod3 col)"
  echo "  V(m3_iout_0)  = " $&V(m3_iout_0)  "  (mod3 KCL bus, chip top output)"

  * Ascending level shifts (PMOS SF: expect POSITIVE ~+0.65V)
  let shift_01 = V(m1_inp_0) - V(m0_iout_0)
  let shift_12 = V(m2_inp_0) - V(m1_iout_0)
  let shift_23 = V(m3_inp_0) - V(m2_iout_0)
  echo "  Level shift link01 (PMOS SF): " $&shift_01 "V  (expect +0.65V: SF raises)"
  echo "  Level shift link12 (PMOS SF): " $&shift_12 "V"
  echo "  Level shift link23 (PMOS SF): " $&shift_23 "V"
  echo ""

  * Descending prediction path
  echo "  --- Descending prediction path ---"
  echo "  V(m2_pred_0) = " $&V(m2_pred_0)
  echo "  V(m1_pred_0) = " $&V(m1_pred_0)
  echo "  V(m0_pred_0) = " $&V(m0_pred_0)
  echo ""

  * Error flags
  echo "  --- Error flags row 0 (HIGH = fires) ---"
  echo "  ierr_m0_0 = " $&V(ierr_m0_0)
  echo "  ierr_m1_0 = " $&V(ierr_m1_0)
  echo "  ierr_m2_0 = " $&V(ierr_m2_0)
  echo "  ierr_m3_0 = " $&V(ierr_m3_0) "  (i_pred=VSS → always HIGH)"
  echo ""

  * PASS/FAIL: PMOS SF raises voltage (positive shift)
  if shift_01 > 0
    echo "  PASS: link01 shift positive (PMOS SF raises)"
  else
    echo "  WARN: link01 shift non-positive — check PMOS SF"
  end
  if shift_12 > 0
    echo "  PASS: link12 shift positive"
  else
    echo "  WARN: link12 shift non-positive"
  end
  if shift_23 > 0
    echo "  PASS: link23 shift positive"
  else
    echo "  WARN: link23 shift non-positive"
  end

  * Check upper diff pairs receive sufficient input voltage
  if V(m1_inp_0) > 0.6
    echo "  PASS: mod1 inp > 0.6V (PMOS SF spatial fix working)"
  else
    echo "  WARN: mod1 inp too low — spatial pipeline may be dead"
  end

  * §72 fix check: mod1 KCL bus should be balanced (not collapsed)
  if V(m1_iout_0) > 0.3
    echo "  PASS: mod1 iout > 0.3V — diff pair balanced (§72 vcm_iout fix working)"
  else
    echo "  WARN: mod1 iout < 0.3V — vcm_upper mismatch (ref SF gate needs §72 fix)"
  end

  * §72 fix check: vcm_upper should match m1_inp at balance (within 0.1V)
  let vcmu_err = abs(V(vcm_upper_01) - V(m1_inp_0))
  if vcmu_err < 0.1
    echo "  PASS: vcm_upper ≈ m1_inp (§72 reference SF tracking correctly)"
  else
    echo "  WARN: vcm_upper offset " $&vcmu_err "V from m1_inp — check ncm_iout bias"
  end

  if V(ierr_m3_0) > 0.9
    echo "  PASS: mod3 ierr_dig HIGH (top layer fires)"
  else
    echo "  WARN: mod3 ierr_dig LOW"
  end

  write output/t1_4layer_op.raw
  echo "  Saved: output/t1_4layer_op.raw"

  * ──────────────────────────────────────────────────────────────────────────
  * T2: DC sweep — raw_inp_0 ±50mV, signal gain through 4 layers
  * ──────────────────────────────────────────────────────────────────────────
  echo ""
  echo "======================================================"
  echo " T2: DC sweep — ascending signal gain"
  echo "======================================================"

  dc Vinp0 0.85 0.95 0.005

  meas dc Vm0iout0_lo  FIND V(m0_iout_0)  WHEN V(raw_inp_0)=0.86 CROSS=1
  meas dc Vm0iout0_hi  FIND V(m0_iout_0)  WHEN V(raw_inp_0)=0.94 CROSS=1
  meas dc Vm1inp0_lo  FIND V(m1_inp_0)  WHEN V(raw_inp_0)=0.86 CROSS=1
  meas dc Vm1inp0_hi  FIND V(m1_inp_0)  WHEN V(raw_inp_0)=0.94 CROSS=1
  meas dc Vm1iout0_lo  FIND V(m1_iout_0)  WHEN V(raw_inp_0)=0.86 CROSS=1
  meas dc Vm1iout0_hi  FIND V(m1_iout_0)  WHEN V(raw_inp_0)=0.94 CROSS=1
  meas dc Vm2inp0_lo  FIND V(m2_inp_0)  WHEN V(raw_inp_0)=0.86 CROSS=1
  meas dc Vm2inp0_hi  FIND V(m2_inp_0)  WHEN V(raw_inp_0)=0.94 CROSS=1
  meas dc Vm2iout0_lo  FIND V(m2_iout_0)  WHEN V(raw_inp_0)=0.86 CROSS=1
  meas dc Vm2iout0_hi  FIND V(m2_iout_0)  WHEN V(raw_inp_0)=0.94 CROSS=1
  meas dc Vm3inp0_lo  FIND V(m3_inp_0)  WHEN V(raw_inp_0)=0.86 CROSS=1
  meas dc Vm3inp0_hi  FIND V(m3_inp_0)  WHEN V(raw_inp_0)=0.94 CROSS=1
  meas dc Vm3iout0_lo  FIND V(m3_iout_0)  WHEN V(raw_inp_0)=0.86 CROSS=1
  meas dc Vm3iout0_hi  FIND V(m3_iout_0)  WHEN V(raw_inp_0)=0.94 CROSS=1

  let dV_m0iout0 = Vm0iout0_hi - Vm0iout0_lo
  echo "  V(m0_iout_0) swing over 80mV: " $&dV_m0iout0 " V"
  let dV_m1inp0 = Vm1inp0_hi - Vm1inp0_lo
  echo "  V(m1_inp_0) swing over 80mV: " $&dV_m1inp0 " V"
  let dV_m1iout0 = Vm1iout0_hi - Vm1iout0_lo
  echo "  V(m1_iout_0) swing over 80mV: " $&dV_m1iout0 " V"
  let dV_m2inp0 = Vm2inp0_hi - Vm2inp0_lo
  echo "  V(m2_inp_0) swing over 80mV: " $&dV_m2inp0 " V"
  let dV_m2iout0 = Vm2iout0_hi - Vm2iout0_lo
  echo "  V(m2_iout_0) swing over 80mV: " $&dV_m2iout0 " V"
  let dV_m3inp0 = Vm3inp0_hi - Vm3inp0_lo
  echo "  V(m3_inp_0) swing over 80mV: " $&dV_m3inp0 " V"
  let dV_m3iout0 = Vm3iout0_hi - Vm3iout0_lo
  echo "  V(m3_iout_0) swing over 80mV: " $&dV_m3iout0 " V"

  echo ""
  let gain_m0iout0 = dV_m0iout0 / 0.08
  echo "  mod0 gain (raw→iout): " $&gain_m0iout0
  let gain_m1inp0 = dV_m1inp0 / dV_m0iout0
  echo "  link01 SF gain: " $&gain_m1inp0
  let gain_m1iout0 = dV_m1iout0 / dV_m1inp0
  echo "  mod1 gain (inp→iout): " $&gain_m1iout0
  let gain_m2inp0 = dV_m2inp0 / dV_m1iout0
  echo "  link12 SF gain: " $&gain_m2inp0
  let gain_m2iout0 = dV_m2iout0 / dV_m2inp0
  echo "  mod2 gain (inp→iout): " $&gain_m2iout0
  let gain_m3inp0 = dV_m3inp0 / dV_m2iout0
  echo "  link23 SF gain: " $&gain_m3inp0
  let gain_m3iout0 = dV_m3iout0 / dV_m3inp0
  echo "  mod3 gain (inp→iout): " $&gain_m3iout0

  let abs_swing_m3 = abs(dV_m3iout0)
  if abs_swing_m3 > 0.001
    echo "  PASS: signal propagates through all 4 layers"
  else
    echo "  FAIL: no signal at mod3 — check PMOS SF ascending path"
  end

  wrdata output/t2_4layer_sweep.csv V(raw_inp_0) V(m0_iout_0) V(m1_inp_0) V(m1_iout_0) V(m2_inp_0) V(m2_iout_0) V(m3_inp_0) V(m3_iout_0)
  write  output/t2_4layer_sweep.raw
  echo "  Saved: output/t2_4layer_sweep.csv  output/t2_4layer_sweep.raw"

  * ──────────────────────────────────────────────────────────────────────────
  * T3: Transient — Hebbian write on mod0 row 0
  * ──────────────────────────────────────────────────────────────────────────
  echo ""
  echo "======================================================"
  echo " T3: Transient — Hebbian write mod0 row0"
  echo "======================================================"

  alter @vinp0[dc] = 1.1

  tran 0.5n 120n uic

  meas tran Vw_t110    FIND V(xmod0.xarray.vw_0_0)  AT=110n
  meas tran Vw_t0      FIND V(xmod0.xarray.vw_0_0)  AT=1n
  meas tran Verr_t60   FIND V(ierr_m0_0)              AT=60n
  meas tran Vwe_t60    FIND V(we_m0_0)                AT=60n

  echo "  V(we_m0_0) at t=60ns:   " $&Vwe_t60  "  (expect 1.8V)"
  echo "  V(ierr_m0_0) at t=60ns: " $&Verr_t60
  echo "  V(vw_0_0) t=1n:   " $&Vw_t0
  echo "  V(vw_0_0) t=110n: " $&Vw_t110

  let dVw = Vw_t110 - Vw_t0
  echo "  Delta Vw = " $&dVw " V"

  let dVw_abs = abs(dVw)
  if dVw_abs > 1e-3
    echo "  PASS: weight changed — Hebbian write functional"
  else
    echo "  NOTE: weight unchanged — ierr_dig or WE path may be blocked"
  end

  wrdata output/t3_4layer_hebb.csv V(xmod0.xarray.vw_0_0) V(ierr_m0_0) V(we_m0_0) V(m0_iout_0)
  write  output/t3_4layer_hebb.raw
  echo "  Saved: output/t3_4layer_hebb.csv"

  echo ""
  echo "======================================================"
  echo " All 4-layer tests complete."
  echo "======================================================"

  quit

.endc

.end
