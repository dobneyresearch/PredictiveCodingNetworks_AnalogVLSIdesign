* Generated by gen_array.py — DO NOT EDIT by hand.
* Regenerate: python3 gen_array.py 16 16
* PCN weight array: 16 rows × 16 columns = 256 MAC cells.
*
* Port convention:
*   inp_col_c / inn_col_c  — differential column inputs (c = 0..15)
*   iout_row_r             — row KCL accumulation bus (r = 0..15)
*   we_row_r               — Hebbian write enable for row r (from hebb_ctrl)
*   v_post_r               — post-synaptic signal for row r (from precision_gate.ierr_dig)
*   vcm vdd vss
*
* Internal nodes:
*   vw_r_c                 — weight capacitor voltage for cell [r][c]
*   iwrite_r_c             — Hebbian update current (hebbian_mult → mac_cell.iwrite)

.subckt pcn_array_16x16
+ inp_col_0 inn_col_0 inp_col_1 inn_col_1 inp_col_2 inn_col_2 inp_col_3 inn_col_3 inp_col_4 inn_col_4 inp_col_5 inn_col_5 inp_col_6 inn_col_6 inp_col_7 inn_col_7 inp_col_8 inn_col_8 inp_col_9 inn_col_9 inp_col_10 inn_col_10 inp_col_11 inn_col_11 inp_col_12 inn_col_12 inp_col_13 inn_col_13 inp_col_14 inn_col_14 inp_col_15 inn_col_15
+ iout_row_0 iout_row_1 iout_row_2 iout_row_3 iout_row_4 iout_row_5 iout_row_6 iout_row_7 iout_row_8 iout_row_9 iout_row_10 iout_row_11 iout_row_12 iout_row_13 iout_row_14 iout_row_15
+ we_row_0 we_row_1 we_row_2 we_row_3 we_row_4 we_row_5 we_row_6 we_row_7 we_row_8 we_row_9 we_row_10 we_row_11 we_row_12 we_row_13 we_row_14 we_row_15
+ v_post_0 v_post_1 v_post_2 v_post_3 v_post_4 v_post_5 v_post_6 v_post_7 v_post_8 v_post_9 v_post_10 v_post_11 v_post_12 v_post_13 v_post_14 v_post_15
+ vcm vdd vss

* ── MAC cells ────────────────────────────────────────────────────────────────
* X_mac_r_c  iout_row_r  inp_col_c  inn_col_c  vw_r_c  iwrite_r_c  we_row_r  vdd vss  mac_cell
X_mac_0_0  iout_row_0  inp_col_0  inn_col_0  vw_0_0  iwrite_0_0  we_row_0  vdd vss  mac_cell
X_mac_0_1  iout_row_0  inp_col_1  inn_col_1  vw_0_1  iwrite_0_1  we_row_0  vdd vss  mac_cell
X_mac_0_2  iout_row_0  inp_col_2  inn_col_2  vw_0_2  iwrite_0_2  we_row_0  vdd vss  mac_cell
X_mac_0_3  iout_row_0  inp_col_3  inn_col_3  vw_0_3  iwrite_0_3  we_row_0  vdd vss  mac_cell
X_mac_0_4  iout_row_0  inp_col_4  inn_col_4  vw_0_4  iwrite_0_4  we_row_0  vdd vss  mac_cell
X_mac_0_5  iout_row_0  inp_col_5  inn_col_5  vw_0_5  iwrite_0_5  we_row_0  vdd vss  mac_cell
X_mac_0_6  iout_row_0  inp_col_6  inn_col_6  vw_0_6  iwrite_0_6  we_row_0  vdd vss  mac_cell
X_mac_0_7  iout_row_0  inp_col_7  inn_col_7  vw_0_7  iwrite_0_7  we_row_0  vdd vss  mac_cell
X_mac_0_8  iout_row_0  inp_col_8  inn_col_8  vw_0_8  iwrite_0_8  we_row_0  vdd vss  mac_cell
X_mac_0_9  iout_row_0  inp_col_9  inn_col_9  vw_0_9  iwrite_0_9  we_row_0  vdd vss  mac_cell
X_mac_0_10  iout_row_0  inp_col_10  inn_col_10  vw_0_10  iwrite_0_10  we_row_0  vdd vss  mac_cell
X_mac_0_11  iout_row_0  inp_col_11  inn_col_11  vw_0_11  iwrite_0_11  we_row_0  vdd vss  mac_cell
X_mac_0_12  iout_row_0  inp_col_12  inn_col_12  vw_0_12  iwrite_0_12  we_row_0  vdd vss  mac_cell
X_mac_0_13  iout_row_0  inp_col_13  inn_col_13  vw_0_13  iwrite_0_13  we_row_0  vdd vss  mac_cell
X_mac_0_14  iout_row_0  inp_col_14  inn_col_14  vw_0_14  iwrite_0_14  we_row_0  vdd vss  mac_cell
X_mac_0_15  iout_row_0  inp_col_15  inn_col_15  vw_0_15  iwrite_0_15  we_row_0  vdd vss  mac_cell

X_mac_1_0  iout_row_1  inp_col_0  inn_col_0  vw_1_0  iwrite_1_0  we_row_1  vdd vss  mac_cell
X_mac_1_1  iout_row_1  inp_col_1  inn_col_1  vw_1_1  iwrite_1_1  we_row_1  vdd vss  mac_cell
X_mac_1_2  iout_row_1  inp_col_2  inn_col_2  vw_1_2  iwrite_1_2  we_row_1  vdd vss  mac_cell
X_mac_1_3  iout_row_1  inp_col_3  inn_col_3  vw_1_3  iwrite_1_3  we_row_1  vdd vss  mac_cell
X_mac_1_4  iout_row_1  inp_col_4  inn_col_4  vw_1_4  iwrite_1_4  we_row_1  vdd vss  mac_cell
X_mac_1_5  iout_row_1  inp_col_5  inn_col_5  vw_1_5  iwrite_1_5  we_row_1  vdd vss  mac_cell
X_mac_1_6  iout_row_1  inp_col_6  inn_col_6  vw_1_6  iwrite_1_6  we_row_1  vdd vss  mac_cell
X_mac_1_7  iout_row_1  inp_col_7  inn_col_7  vw_1_7  iwrite_1_7  we_row_1  vdd vss  mac_cell
X_mac_1_8  iout_row_1  inp_col_8  inn_col_8  vw_1_8  iwrite_1_8  we_row_1  vdd vss  mac_cell
X_mac_1_9  iout_row_1  inp_col_9  inn_col_9  vw_1_9  iwrite_1_9  we_row_1  vdd vss  mac_cell
X_mac_1_10  iout_row_1  inp_col_10  inn_col_10  vw_1_10  iwrite_1_10  we_row_1  vdd vss  mac_cell
X_mac_1_11  iout_row_1  inp_col_11  inn_col_11  vw_1_11  iwrite_1_11  we_row_1  vdd vss  mac_cell
X_mac_1_12  iout_row_1  inp_col_12  inn_col_12  vw_1_12  iwrite_1_12  we_row_1  vdd vss  mac_cell
X_mac_1_13  iout_row_1  inp_col_13  inn_col_13  vw_1_13  iwrite_1_13  we_row_1  vdd vss  mac_cell
X_mac_1_14  iout_row_1  inp_col_14  inn_col_14  vw_1_14  iwrite_1_14  we_row_1  vdd vss  mac_cell
X_mac_1_15  iout_row_1  inp_col_15  inn_col_15  vw_1_15  iwrite_1_15  we_row_1  vdd vss  mac_cell

X_mac_2_0  iout_row_2  inp_col_0  inn_col_0  vw_2_0  iwrite_2_0  we_row_2  vdd vss  mac_cell
X_mac_2_1  iout_row_2  inp_col_1  inn_col_1  vw_2_1  iwrite_2_1  we_row_2  vdd vss  mac_cell
X_mac_2_2  iout_row_2  inp_col_2  inn_col_2  vw_2_2  iwrite_2_2  we_row_2  vdd vss  mac_cell
X_mac_2_3  iout_row_2  inp_col_3  inn_col_3  vw_2_3  iwrite_2_3  we_row_2  vdd vss  mac_cell
X_mac_2_4  iout_row_2  inp_col_4  inn_col_4  vw_2_4  iwrite_2_4  we_row_2  vdd vss  mac_cell
X_mac_2_5  iout_row_2  inp_col_5  inn_col_5  vw_2_5  iwrite_2_5  we_row_2  vdd vss  mac_cell
X_mac_2_6  iout_row_2  inp_col_6  inn_col_6  vw_2_6  iwrite_2_6  we_row_2  vdd vss  mac_cell
X_mac_2_7  iout_row_2  inp_col_7  inn_col_7  vw_2_7  iwrite_2_7  we_row_2  vdd vss  mac_cell
X_mac_2_8  iout_row_2  inp_col_8  inn_col_8  vw_2_8  iwrite_2_8  we_row_2  vdd vss  mac_cell
X_mac_2_9  iout_row_2  inp_col_9  inn_col_9  vw_2_9  iwrite_2_9  we_row_2  vdd vss  mac_cell
X_mac_2_10  iout_row_2  inp_col_10  inn_col_10  vw_2_10  iwrite_2_10  we_row_2  vdd vss  mac_cell
X_mac_2_11  iout_row_2  inp_col_11  inn_col_11  vw_2_11  iwrite_2_11  we_row_2  vdd vss  mac_cell
X_mac_2_12  iout_row_2  inp_col_12  inn_col_12  vw_2_12  iwrite_2_12  we_row_2  vdd vss  mac_cell
X_mac_2_13  iout_row_2  inp_col_13  inn_col_13  vw_2_13  iwrite_2_13  we_row_2  vdd vss  mac_cell
X_mac_2_14  iout_row_2  inp_col_14  inn_col_14  vw_2_14  iwrite_2_14  we_row_2  vdd vss  mac_cell
X_mac_2_15  iout_row_2  inp_col_15  inn_col_15  vw_2_15  iwrite_2_15  we_row_2  vdd vss  mac_cell

X_mac_3_0  iout_row_3  inp_col_0  inn_col_0  vw_3_0  iwrite_3_0  we_row_3  vdd vss  mac_cell
X_mac_3_1  iout_row_3  inp_col_1  inn_col_1  vw_3_1  iwrite_3_1  we_row_3  vdd vss  mac_cell
X_mac_3_2  iout_row_3  inp_col_2  inn_col_2  vw_3_2  iwrite_3_2  we_row_3  vdd vss  mac_cell
X_mac_3_3  iout_row_3  inp_col_3  inn_col_3  vw_3_3  iwrite_3_3  we_row_3  vdd vss  mac_cell
X_mac_3_4  iout_row_3  inp_col_4  inn_col_4  vw_3_4  iwrite_3_4  we_row_3  vdd vss  mac_cell
X_mac_3_5  iout_row_3  inp_col_5  inn_col_5  vw_3_5  iwrite_3_5  we_row_3  vdd vss  mac_cell
X_mac_3_6  iout_row_3  inp_col_6  inn_col_6  vw_3_6  iwrite_3_6  we_row_3  vdd vss  mac_cell
X_mac_3_7  iout_row_3  inp_col_7  inn_col_7  vw_3_7  iwrite_3_7  we_row_3  vdd vss  mac_cell
X_mac_3_8  iout_row_3  inp_col_8  inn_col_8  vw_3_8  iwrite_3_8  we_row_3  vdd vss  mac_cell
X_mac_3_9  iout_row_3  inp_col_9  inn_col_9  vw_3_9  iwrite_3_9  we_row_3  vdd vss  mac_cell
X_mac_3_10  iout_row_3  inp_col_10  inn_col_10  vw_3_10  iwrite_3_10  we_row_3  vdd vss  mac_cell
X_mac_3_11  iout_row_3  inp_col_11  inn_col_11  vw_3_11  iwrite_3_11  we_row_3  vdd vss  mac_cell
X_mac_3_12  iout_row_3  inp_col_12  inn_col_12  vw_3_12  iwrite_3_12  we_row_3  vdd vss  mac_cell
X_mac_3_13  iout_row_3  inp_col_13  inn_col_13  vw_3_13  iwrite_3_13  we_row_3  vdd vss  mac_cell
X_mac_3_14  iout_row_3  inp_col_14  inn_col_14  vw_3_14  iwrite_3_14  we_row_3  vdd vss  mac_cell
X_mac_3_15  iout_row_3  inp_col_15  inn_col_15  vw_3_15  iwrite_3_15  we_row_3  vdd vss  mac_cell

X_mac_4_0  iout_row_4  inp_col_0  inn_col_0  vw_4_0  iwrite_4_0  we_row_4  vdd vss  mac_cell
X_mac_4_1  iout_row_4  inp_col_1  inn_col_1  vw_4_1  iwrite_4_1  we_row_4  vdd vss  mac_cell
X_mac_4_2  iout_row_4  inp_col_2  inn_col_2  vw_4_2  iwrite_4_2  we_row_4  vdd vss  mac_cell
X_mac_4_3  iout_row_4  inp_col_3  inn_col_3  vw_4_3  iwrite_4_3  we_row_4  vdd vss  mac_cell
X_mac_4_4  iout_row_4  inp_col_4  inn_col_4  vw_4_4  iwrite_4_4  we_row_4  vdd vss  mac_cell
X_mac_4_5  iout_row_4  inp_col_5  inn_col_5  vw_4_5  iwrite_4_5  we_row_4  vdd vss  mac_cell
X_mac_4_6  iout_row_4  inp_col_6  inn_col_6  vw_4_6  iwrite_4_6  we_row_4  vdd vss  mac_cell
X_mac_4_7  iout_row_4  inp_col_7  inn_col_7  vw_4_7  iwrite_4_7  we_row_4  vdd vss  mac_cell
X_mac_4_8  iout_row_4  inp_col_8  inn_col_8  vw_4_8  iwrite_4_8  we_row_4  vdd vss  mac_cell
X_mac_4_9  iout_row_4  inp_col_9  inn_col_9  vw_4_9  iwrite_4_9  we_row_4  vdd vss  mac_cell
X_mac_4_10  iout_row_4  inp_col_10  inn_col_10  vw_4_10  iwrite_4_10  we_row_4  vdd vss  mac_cell
X_mac_4_11  iout_row_4  inp_col_11  inn_col_11  vw_4_11  iwrite_4_11  we_row_4  vdd vss  mac_cell
X_mac_4_12  iout_row_4  inp_col_12  inn_col_12  vw_4_12  iwrite_4_12  we_row_4  vdd vss  mac_cell
X_mac_4_13  iout_row_4  inp_col_13  inn_col_13  vw_4_13  iwrite_4_13  we_row_4  vdd vss  mac_cell
X_mac_4_14  iout_row_4  inp_col_14  inn_col_14  vw_4_14  iwrite_4_14  we_row_4  vdd vss  mac_cell
X_mac_4_15  iout_row_4  inp_col_15  inn_col_15  vw_4_15  iwrite_4_15  we_row_4  vdd vss  mac_cell

X_mac_5_0  iout_row_5  inp_col_0  inn_col_0  vw_5_0  iwrite_5_0  we_row_5  vdd vss  mac_cell
X_mac_5_1  iout_row_5  inp_col_1  inn_col_1  vw_5_1  iwrite_5_1  we_row_5  vdd vss  mac_cell
X_mac_5_2  iout_row_5  inp_col_2  inn_col_2  vw_5_2  iwrite_5_2  we_row_5  vdd vss  mac_cell
X_mac_5_3  iout_row_5  inp_col_3  inn_col_3  vw_5_3  iwrite_5_3  we_row_5  vdd vss  mac_cell
X_mac_5_4  iout_row_5  inp_col_4  inn_col_4  vw_5_4  iwrite_5_4  we_row_5  vdd vss  mac_cell
X_mac_5_5  iout_row_5  inp_col_5  inn_col_5  vw_5_5  iwrite_5_5  we_row_5  vdd vss  mac_cell
X_mac_5_6  iout_row_5  inp_col_6  inn_col_6  vw_5_6  iwrite_5_6  we_row_5  vdd vss  mac_cell
X_mac_5_7  iout_row_5  inp_col_7  inn_col_7  vw_5_7  iwrite_5_7  we_row_5  vdd vss  mac_cell
X_mac_5_8  iout_row_5  inp_col_8  inn_col_8  vw_5_8  iwrite_5_8  we_row_5  vdd vss  mac_cell
X_mac_5_9  iout_row_5  inp_col_9  inn_col_9  vw_5_9  iwrite_5_9  we_row_5  vdd vss  mac_cell
X_mac_5_10  iout_row_5  inp_col_10  inn_col_10  vw_5_10  iwrite_5_10  we_row_5  vdd vss  mac_cell
X_mac_5_11  iout_row_5  inp_col_11  inn_col_11  vw_5_11  iwrite_5_11  we_row_5  vdd vss  mac_cell
X_mac_5_12  iout_row_5  inp_col_12  inn_col_12  vw_5_12  iwrite_5_12  we_row_5  vdd vss  mac_cell
X_mac_5_13  iout_row_5  inp_col_13  inn_col_13  vw_5_13  iwrite_5_13  we_row_5  vdd vss  mac_cell
X_mac_5_14  iout_row_5  inp_col_14  inn_col_14  vw_5_14  iwrite_5_14  we_row_5  vdd vss  mac_cell
X_mac_5_15  iout_row_5  inp_col_15  inn_col_15  vw_5_15  iwrite_5_15  we_row_5  vdd vss  mac_cell

X_mac_6_0  iout_row_6  inp_col_0  inn_col_0  vw_6_0  iwrite_6_0  we_row_6  vdd vss  mac_cell
X_mac_6_1  iout_row_6  inp_col_1  inn_col_1  vw_6_1  iwrite_6_1  we_row_6  vdd vss  mac_cell
X_mac_6_2  iout_row_6  inp_col_2  inn_col_2  vw_6_2  iwrite_6_2  we_row_6  vdd vss  mac_cell
X_mac_6_3  iout_row_6  inp_col_3  inn_col_3  vw_6_3  iwrite_6_3  we_row_6  vdd vss  mac_cell
X_mac_6_4  iout_row_6  inp_col_4  inn_col_4  vw_6_4  iwrite_6_4  we_row_6  vdd vss  mac_cell
X_mac_6_5  iout_row_6  inp_col_5  inn_col_5  vw_6_5  iwrite_6_5  we_row_6  vdd vss  mac_cell
X_mac_6_6  iout_row_6  inp_col_6  inn_col_6  vw_6_6  iwrite_6_6  we_row_6  vdd vss  mac_cell
X_mac_6_7  iout_row_6  inp_col_7  inn_col_7  vw_6_7  iwrite_6_7  we_row_6  vdd vss  mac_cell
X_mac_6_8  iout_row_6  inp_col_8  inn_col_8  vw_6_8  iwrite_6_8  we_row_6  vdd vss  mac_cell
X_mac_6_9  iout_row_6  inp_col_9  inn_col_9  vw_6_9  iwrite_6_9  we_row_6  vdd vss  mac_cell
X_mac_6_10  iout_row_6  inp_col_10  inn_col_10  vw_6_10  iwrite_6_10  we_row_6  vdd vss  mac_cell
X_mac_6_11  iout_row_6  inp_col_11  inn_col_11  vw_6_11  iwrite_6_11  we_row_6  vdd vss  mac_cell
X_mac_6_12  iout_row_6  inp_col_12  inn_col_12  vw_6_12  iwrite_6_12  we_row_6  vdd vss  mac_cell
X_mac_6_13  iout_row_6  inp_col_13  inn_col_13  vw_6_13  iwrite_6_13  we_row_6  vdd vss  mac_cell
X_mac_6_14  iout_row_6  inp_col_14  inn_col_14  vw_6_14  iwrite_6_14  we_row_6  vdd vss  mac_cell
X_mac_6_15  iout_row_6  inp_col_15  inn_col_15  vw_6_15  iwrite_6_15  we_row_6  vdd vss  mac_cell

X_mac_7_0  iout_row_7  inp_col_0  inn_col_0  vw_7_0  iwrite_7_0  we_row_7  vdd vss  mac_cell
X_mac_7_1  iout_row_7  inp_col_1  inn_col_1  vw_7_1  iwrite_7_1  we_row_7  vdd vss  mac_cell
X_mac_7_2  iout_row_7  inp_col_2  inn_col_2  vw_7_2  iwrite_7_2  we_row_7  vdd vss  mac_cell
X_mac_7_3  iout_row_7  inp_col_3  inn_col_3  vw_7_3  iwrite_7_3  we_row_7  vdd vss  mac_cell
X_mac_7_4  iout_row_7  inp_col_4  inn_col_4  vw_7_4  iwrite_7_4  we_row_7  vdd vss  mac_cell
X_mac_7_5  iout_row_7  inp_col_5  inn_col_5  vw_7_5  iwrite_7_5  we_row_7  vdd vss  mac_cell
X_mac_7_6  iout_row_7  inp_col_6  inn_col_6  vw_7_6  iwrite_7_6  we_row_7  vdd vss  mac_cell
X_mac_7_7  iout_row_7  inp_col_7  inn_col_7  vw_7_7  iwrite_7_7  we_row_7  vdd vss  mac_cell
X_mac_7_8  iout_row_7  inp_col_8  inn_col_8  vw_7_8  iwrite_7_8  we_row_7  vdd vss  mac_cell
X_mac_7_9  iout_row_7  inp_col_9  inn_col_9  vw_7_9  iwrite_7_9  we_row_7  vdd vss  mac_cell
X_mac_7_10  iout_row_7  inp_col_10  inn_col_10  vw_7_10  iwrite_7_10  we_row_7  vdd vss  mac_cell
X_mac_7_11  iout_row_7  inp_col_11  inn_col_11  vw_7_11  iwrite_7_11  we_row_7  vdd vss  mac_cell
X_mac_7_12  iout_row_7  inp_col_12  inn_col_12  vw_7_12  iwrite_7_12  we_row_7  vdd vss  mac_cell
X_mac_7_13  iout_row_7  inp_col_13  inn_col_13  vw_7_13  iwrite_7_13  we_row_7  vdd vss  mac_cell
X_mac_7_14  iout_row_7  inp_col_14  inn_col_14  vw_7_14  iwrite_7_14  we_row_7  vdd vss  mac_cell
X_mac_7_15  iout_row_7  inp_col_15  inn_col_15  vw_7_15  iwrite_7_15  we_row_7  vdd vss  mac_cell

X_mac_8_0  iout_row_8  inp_col_0  inn_col_0  vw_8_0  iwrite_8_0  we_row_8  vdd vss  mac_cell
X_mac_8_1  iout_row_8  inp_col_1  inn_col_1  vw_8_1  iwrite_8_1  we_row_8  vdd vss  mac_cell
X_mac_8_2  iout_row_8  inp_col_2  inn_col_2  vw_8_2  iwrite_8_2  we_row_8  vdd vss  mac_cell
X_mac_8_3  iout_row_8  inp_col_3  inn_col_3  vw_8_3  iwrite_8_3  we_row_8  vdd vss  mac_cell
X_mac_8_4  iout_row_8  inp_col_4  inn_col_4  vw_8_4  iwrite_8_4  we_row_8  vdd vss  mac_cell
X_mac_8_5  iout_row_8  inp_col_5  inn_col_5  vw_8_5  iwrite_8_5  we_row_8  vdd vss  mac_cell
X_mac_8_6  iout_row_8  inp_col_6  inn_col_6  vw_8_6  iwrite_8_6  we_row_8  vdd vss  mac_cell
X_mac_8_7  iout_row_8  inp_col_7  inn_col_7  vw_8_7  iwrite_8_7  we_row_8  vdd vss  mac_cell
X_mac_8_8  iout_row_8  inp_col_8  inn_col_8  vw_8_8  iwrite_8_8  we_row_8  vdd vss  mac_cell
X_mac_8_9  iout_row_8  inp_col_9  inn_col_9  vw_8_9  iwrite_8_9  we_row_8  vdd vss  mac_cell
X_mac_8_10  iout_row_8  inp_col_10  inn_col_10  vw_8_10  iwrite_8_10  we_row_8  vdd vss  mac_cell
X_mac_8_11  iout_row_8  inp_col_11  inn_col_11  vw_8_11  iwrite_8_11  we_row_8  vdd vss  mac_cell
X_mac_8_12  iout_row_8  inp_col_12  inn_col_12  vw_8_12  iwrite_8_12  we_row_8  vdd vss  mac_cell
X_mac_8_13  iout_row_8  inp_col_13  inn_col_13  vw_8_13  iwrite_8_13  we_row_8  vdd vss  mac_cell
X_mac_8_14  iout_row_8  inp_col_14  inn_col_14  vw_8_14  iwrite_8_14  we_row_8  vdd vss  mac_cell
X_mac_8_15  iout_row_8  inp_col_15  inn_col_15  vw_8_15  iwrite_8_15  we_row_8  vdd vss  mac_cell

X_mac_9_0  iout_row_9  inp_col_0  inn_col_0  vw_9_0  iwrite_9_0  we_row_9  vdd vss  mac_cell
X_mac_9_1  iout_row_9  inp_col_1  inn_col_1  vw_9_1  iwrite_9_1  we_row_9  vdd vss  mac_cell
X_mac_9_2  iout_row_9  inp_col_2  inn_col_2  vw_9_2  iwrite_9_2  we_row_9  vdd vss  mac_cell
X_mac_9_3  iout_row_9  inp_col_3  inn_col_3  vw_9_3  iwrite_9_3  we_row_9  vdd vss  mac_cell
X_mac_9_4  iout_row_9  inp_col_4  inn_col_4  vw_9_4  iwrite_9_4  we_row_9  vdd vss  mac_cell
X_mac_9_5  iout_row_9  inp_col_5  inn_col_5  vw_9_5  iwrite_9_5  we_row_9  vdd vss  mac_cell
X_mac_9_6  iout_row_9  inp_col_6  inn_col_6  vw_9_6  iwrite_9_6  we_row_9  vdd vss  mac_cell
X_mac_9_7  iout_row_9  inp_col_7  inn_col_7  vw_9_7  iwrite_9_7  we_row_9  vdd vss  mac_cell
X_mac_9_8  iout_row_9  inp_col_8  inn_col_8  vw_9_8  iwrite_9_8  we_row_9  vdd vss  mac_cell
X_mac_9_9  iout_row_9  inp_col_9  inn_col_9  vw_9_9  iwrite_9_9  we_row_9  vdd vss  mac_cell
X_mac_9_10  iout_row_9  inp_col_10  inn_col_10  vw_9_10  iwrite_9_10  we_row_9  vdd vss  mac_cell
X_mac_9_11  iout_row_9  inp_col_11  inn_col_11  vw_9_11  iwrite_9_11  we_row_9  vdd vss  mac_cell
X_mac_9_12  iout_row_9  inp_col_12  inn_col_12  vw_9_12  iwrite_9_12  we_row_9  vdd vss  mac_cell
X_mac_9_13  iout_row_9  inp_col_13  inn_col_13  vw_9_13  iwrite_9_13  we_row_9  vdd vss  mac_cell
X_mac_9_14  iout_row_9  inp_col_14  inn_col_14  vw_9_14  iwrite_9_14  we_row_9  vdd vss  mac_cell
X_mac_9_15  iout_row_9  inp_col_15  inn_col_15  vw_9_15  iwrite_9_15  we_row_9  vdd vss  mac_cell

X_mac_10_0  iout_row_10  inp_col_0  inn_col_0  vw_10_0  iwrite_10_0  we_row_10  vdd vss  mac_cell
X_mac_10_1  iout_row_10  inp_col_1  inn_col_1  vw_10_1  iwrite_10_1  we_row_10  vdd vss  mac_cell
X_mac_10_2  iout_row_10  inp_col_2  inn_col_2  vw_10_2  iwrite_10_2  we_row_10  vdd vss  mac_cell
X_mac_10_3  iout_row_10  inp_col_3  inn_col_3  vw_10_3  iwrite_10_3  we_row_10  vdd vss  mac_cell
X_mac_10_4  iout_row_10  inp_col_4  inn_col_4  vw_10_4  iwrite_10_4  we_row_10  vdd vss  mac_cell
X_mac_10_5  iout_row_10  inp_col_5  inn_col_5  vw_10_5  iwrite_10_5  we_row_10  vdd vss  mac_cell
X_mac_10_6  iout_row_10  inp_col_6  inn_col_6  vw_10_6  iwrite_10_6  we_row_10  vdd vss  mac_cell
X_mac_10_7  iout_row_10  inp_col_7  inn_col_7  vw_10_7  iwrite_10_7  we_row_10  vdd vss  mac_cell
X_mac_10_8  iout_row_10  inp_col_8  inn_col_8  vw_10_8  iwrite_10_8  we_row_10  vdd vss  mac_cell
X_mac_10_9  iout_row_10  inp_col_9  inn_col_9  vw_10_9  iwrite_10_9  we_row_10  vdd vss  mac_cell
X_mac_10_10  iout_row_10  inp_col_10  inn_col_10  vw_10_10  iwrite_10_10  we_row_10  vdd vss  mac_cell
X_mac_10_11  iout_row_10  inp_col_11  inn_col_11  vw_10_11  iwrite_10_11  we_row_10  vdd vss  mac_cell
X_mac_10_12  iout_row_10  inp_col_12  inn_col_12  vw_10_12  iwrite_10_12  we_row_10  vdd vss  mac_cell
X_mac_10_13  iout_row_10  inp_col_13  inn_col_13  vw_10_13  iwrite_10_13  we_row_10  vdd vss  mac_cell
X_mac_10_14  iout_row_10  inp_col_14  inn_col_14  vw_10_14  iwrite_10_14  we_row_10  vdd vss  mac_cell
X_mac_10_15  iout_row_10  inp_col_15  inn_col_15  vw_10_15  iwrite_10_15  we_row_10  vdd vss  mac_cell

X_mac_11_0  iout_row_11  inp_col_0  inn_col_0  vw_11_0  iwrite_11_0  we_row_11  vdd vss  mac_cell
X_mac_11_1  iout_row_11  inp_col_1  inn_col_1  vw_11_1  iwrite_11_1  we_row_11  vdd vss  mac_cell
X_mac_11_2  iout_row_11  inp_col_2  inn_col_2  vw_11_2  iwrite_11_2  we_row_11  vdd vss  mac_cell
X_mac_11_3  iout_row_11  inp_col_3  inn_col_3  vw_11_3  iwrite_11_3  we_row_11  vdd vss  mac_cell
X_mac_11_4  iout_row_11  inp_col_4  inn_col_4  vw_11_4  iwrite_11_4  we_row_11  vdd vss  mac_cell
X_mac_11_5  iout_row_11  inp_col_5  inn_col_5  vw_11_5  iwrite_11_5  we_row_11  vdd vss  mac_cell
X_mac_11_6  iout_row_11  inp_col_6  inn_col_6  vw_11_6  iwrite_11_6  we_row_11  vdd vss  mac_cell
X_mac_11_7  iout_row_11  inp_col_7  inn_col_7  vw_11_7  iwrite_11_7  we_row_11  vdd vss  mac_cell
X_mac_11_8  iout_row_11  inp_col_8  inn_col_8  vw_11_8  iwrite_11_8  we_row_11  vdd vss  mac_cell
X_mac_11_9  iout_row_11  inp_col_9  inn_col_9  vw_11_9  iwrite_11_9  we_row_11  vdd vss  mac_cell
X_mac_11_10  iout_row_11  inp_col_10  inn_col_10  vw_11_10  iwrite_11_10  we_row_11  vdd vss  mac_cell
X_mac_11_11  iout_row_11  inp_col_11  inn_col_11  vw_11_11  iwrite_11_11  we_row_11  vdd vss  mac_cell
X_mac_11_12  iout_row_11  inp_col_12  inn_col_12  vw_11_12  iwrite_11_12  we_row_11  vdd vss  mac_cell
X_mac_11_13  iout_row_11  inp_col_13  inn_col_13  vw_11_13  iwrite_11_13  we_row_11  vdd vss  mac_cell
X_mac_11_14  iout_row_11  inp_col_14  inn_col_14  vw_11_14  iwrite_11_14  we_row_11  vdd vss  mac_cell
X_mac_11_15  iout_row_11  inp_col_15  inn_col_15  vw_11_15  iwrite_11_15  we_row_11  vdd vss  mac_cell

X_mac_12_0  iout_row_12  inp_col_0  inn_col_0  vw_12_0  iwrite_12_0  we_row_12  vdd vss  mac_cell
X_mac_12_1  iout_row_12  inp_col_1  inn_col_1  vw_12_1  iwrite_12_1  we_row_12  vdd vss  mac_cell
X_mac_12_2  iout_row_12  inp_col_2  inn_col_2  vw_12_2  iwrite_12_2  we_row_12  vdd vss  mac_cell
X_mac_12_3  iout_row_12  inp_col_3  inn_col_3  vw_12_3  iwrite_12_3  we_row_12  vdd vss  mac_cell
X_mac_12_4  iout_row_12  inp_col_4  inn_col_4  vw_12_4  iwrite_12_4  we_row_12  vdd vss  mac_cell
X_mac_12_5  iout_row_12  inp_col_5  inn_col_5  vw_12_5  iwrite_12_5  we_row_12  vdd vss  mac_cell
X_mac_12_6  iout_row_12  inp_col_6  inn_col_6  vw_12_6  iwrite_12_6  we_row_12  vdd vss  mac_cell
X_mac_12_7  iout_row_12  inp_col_7  inn_col_7  vw_12_7  iwrite_12_7  we_row_12  vdd vss  mac_cell
X_mac_12_8  iout_row_12  inp_col_8  inn_col_8  vw_12_8  iwrite_12_8  we_row_12  vdd vss  mac_cell
X_mac_12_9  iout_row_12  inp_col_9  inn_col_9  vw_12_9  iwrite_12_9  we_row_12  vdd vss  mac_cell
X_mac_12_10  iout_row_12  inp_col_10  inn_col_10  vw_12_10  iwrite_12_10  we_row_12  vdd vss  mac_cell
X_mac_12_11  iout_row_12  inp_col_11  inn_col_11  vw_12_11  iwrite_12_11  we_row_12  vdd vss  mac_cell
X_mac_12_12  iout_row_12  inp_col_12  inn_col_12  vw_12_12  iwrite_12_12  we_row_12  vdd vss  mac_cell
X_mac_12_13  iout_row_12  inp_col_13  inn_col_13  vw_12_13  iwrite_12_13  we_row_12  vdd vss  mac_cell
X_mac_12_14  iout_row_12  inp_col_14  inn_col_14  vw_12_14  iwrite_12_14  we_row_12  vdd vss  mac_cell
X_mac_12_15  iout_row_12  inp_col_15  inn_col_15  vw_12_15  iwrite_12_15  we_row_12  vdd vss  mac_cell

X_mac_13_0  iout_row_13  inp_col_0  inn_col_0  vw_13_0  iwrite_13_0  we_row_13  vdd vss  mac_cell
X_mac_13_1  iout_row_13  inp_col_1  inn_col_1  vw_13_1  iwrite_13_1  we_row_13  vdd vss  mac_cell
X_mac_13_2  iout_row_13  inp_col_2  inn_col_2  vw_13_2  iwrite_13_2  we_row_13  vdd vss  mac_cell
X_mac_13_3  iout_row_13  inp_col_3  inn_col_3  vw_13_3  iwrite_13_3  we_row_13  vdd vss  mac_cell
X_mac_13_4  iout_row_13  inp_col_4  inn_col_4  vw_13_4  iwrite_13_4  we_row_13  vdd vss  mac_cell
X_mac_13_5  iout_row_13  inp_col_5  inn_col_5  vw_13_5  iwrite_13_5  we_row_13  vdd vss  mac_cell
X_mac_13_6  iout_row_13  inp_col_6  inn_col_6  vw_13_6  iwrite_13_6  we_row_13  vdd vss  mac_cell
X_mac_13_7  iout_row_13  inp_col_7  inn_col_7  vw_13_7  iwrite_13_7  we_row_13  vdd vss  mac_cell
X_mac_13_8  iout_row_13  inp_col_8  inn_col_8  vw_13_8  iwrite_13_8  we_row_13  vdd vss  mac_cell
X_mac_13_9  iout_row_13  inp_col_9  inn_col_9  vw_13_9  iwrite_13_9  we_row_13  vdd vss  mac_cell
X_mac_13_10  iout_row_13  inp_col_10  inn_col_10  vw_13_10  iwrite_13_10  we_row_13  vdd vss  mac_cell
X_mac_13_11  iout_row_13  inp_col_11  inn_col_11  vw_13_11  iwrite_13_11  we_row_13  vdd vss  mac_cell
X_mac_13_12  iout_row_13  inp_col_12  inn_col_12  vw_13_12  iwrite_13_12  we_row_13  vdd vss  mac_cell
X_mac_13_13  iout_row_13  inp_col_13  inn_col_13  vw_13_13  iwrite_13_13  we_row_13  vdd vss  mac_cell
X_mac_13_14  iout_row_13  inp_col_14  inn_col_14  vw_13_14  iwrite_13_14  we_row_13  vdd vss  mac_cell
X_mac_13_15  iout_row_13  inp_col_15  inn_col_15  vw_13_15  iwrite_13_15  we_row_13  vdd vss  mac_cell

X_mac_14_0  iout_row_14  inp_col_0  inn_col_0  vw_14_0  iwrite_14_0  we_row_14  vdd vss  mac_cell
X_mac_14_1  iout_row_14  inp_col_1  inn_col_1  vw_14_1  iwrite_14_1  we_row_14  vdd vss  mac_cell
X_mac_14_2  iout_row_14  inp_col_2  inn_col_2  vw_14_2  iwrite_14_2  we_row_14  vdd vss  mac_cell
X_mac_14_3  iout_row_14  inp_col_3  inn_col_3  vw_14_3  iwrite_14_3  we_row_14  vdd vss  mac_cell
X_mac_14_4  iout_row_14  inp_col_4  inn_col_4  vw_14_4  iwrite_14_4  we_row_14  vdd vss  mac_cell
X_mac_14_5  iout_row_14  inp_col_5  inn_col_5  vw_14_5  iwrite_14_5  we_row_14  vdd vss  mac_cell
X_mac_14_6  iout_row_14  inp_col_6  inn_col_6  vw_14_6  iwrite_14_6  we_row_14  vdd vss  mac_cell
X_mac_14_7  iout_row_14  inp_col_7  inn_col_7  vw_14_7  iwrite_14_7  we_row_14  vdd vss  mac_cell
X_mac_14_8  iout_row_14  inp_col_8  inn_col_8  vw_14_8  iwrite_14_8  we_row_14  vdd vss  mac_cell
X_mac_14_9  iout_row_14  inp_col_9  inn_col_9  vw_14_9  iwrite_14_9  we_row_14  vdd vss  mac_cell
X_mac_14_10  iout_row_14  inp_col_10  inn_col_10  vw_14_10  iwrite_14_10  we_row_14  vdd vss  mac_cell
X_mac_14_11  iout_row_14  inp_col_11  inn_col_11  vw_14_11  iwrite_14_11  we_row_14  vdd vss  mac_cell
X_mac_14_12  iout_row_14  inp_col_12  inn_col_12  vw_14_12  iwrite_14_12  we_row_14  vdd vss  mac_cell
X_mac_14_13  iout_row_14  inp_col_13  inn_col_13  vw_14_13  iwrite_14_13  we_row_14  vdd vss  mac_cell
X_mac_14_14  iout_row_14  inp_col_14  inn_col_14  vw_14_14  iwrite_14_14  we_row_14  vdd vss  mac_cell
X_mac_14_15  iout_row_14  inp_col_15  inn_col_15  vw_14_15  iwrite_14_15  we_row_14  vdd vss  mac_cell

X_mac_15_0  iout_row_15  inp_col_0  inn_col_0  vw_15_0  iwrite_15_0  we_row_15  vdd vss  mac_cell
X_mac_15_1  iout_row_15  inp_col_1  inn_col_1  vw_15_1  iwrite_15_1  we_row_15  vdd vss  mac_cell
X_mac_15_2  iout_row_15  inp_col_2  inn_col_2  vw_15_2  iwrite_15_2  we_row_15  vdd vss  mac_cell
X_mac_15_3  iout_row_15  inp_col_3  inn_col_3  vw_15_3  iwrite_15_3  we_row_15  vdd vss  mac_cell
X_mac_15_4  iout_row_15  inp_col_4  inn_col_4  vw_15_4  iwrite_15_4  we_row_15  vdd vss  mac_cell
X_mac_15_5  iout_row_15  inp_col_5  inn_col_5  vw_15_5  iwrite_15_5  we_row_15  vdd vss  mac_cell
X_mac_15_6  iout_row_15  inp_col_6  inn_col_6  vw_15_6  iwrite_15_6  we_row_15  vdd vss  mac_cell
X_mac_15_7  iout_row_15  inp_col_7  inn_col_7  vw_15_7  iwrite_15_7  we_row_15  vdd vss  mac_cell
X_mac_15_8  iout_row_15  inp_col_8  inn_col_8  vw_15_8  iwrite_15_8  we_row_15  vdd vss  mac_cell
X_mac_15_9  iout_row_15  inp_col_9  inn_col_9  vw_15_9  iwrite_15_9  we_row_15  vdd vss  mac_cell
X_mac_15_10  iout_row_15  inp_col_10  inn_col_10  vw_15_10  iwrite_15_10  we_row_15  vdd vss  mac_cell
X_mac_15_11  iout_row_15  inp_col_11  inn_col_11  vw_15_11  iwrite_15_11  we_row_15  vdd vss  mac_cell
X_mac_15_12  iout_row_15  inp_col_12  inn_col_12  vw_15_12  iwrite_15_12  we_row_15  vdd vss  mac_cell
X_mac_15_13  iout_row_15  inp_col_13  inn_col_13  vw_15_13  iwrite_15_13  we_row_15  vdd vss  mac_cell
X_mac_15_14  iout_row_15  inp_col_14  inn_col_14  vw_15_14  iwrite_15_14  we_row_15  vdd vss  mac_cell
X_mac_15_15  iout_row_15  inp_col_15  inn_col_15  vw_15_15  iwrite_15_15  we_row_15  vdd vss  mac_cell

* ── Hebbian multipliers ──────────────────────────────────────────────────────
* X_hebb_r_c  iwrite_r_c  v_pre(=inp_col_c)  v_post_r  vcm  vdd vss  hebbian_mult
X_hebb_0_0  iwrite_0_0  inp_col_0  v_post_0  vcm vdd vss  hebbian_mult
X_hebb_0_1  iwrite_0_1  inp_col_1  v_post_0  vcm vdd vss  hebbian_mult
X_hebb_0_2  iwrite_0_2  inp_col_2  v_post_0  vcm vdd vss  hebbian_mult
X_hebb_0_3  iwrite_0_3  inp_col_3  v_post_0  vcm vdd vss  hebbian_mult
X_hebb_0_4  iwrite_0_4  inp_col_4  v_post_0  vcm vdd vss  hebbian_mult
X_hebb_0_5  iwrite_0_5  inp_col_5  v_post_0  vcm vdd vss  hebbian_mult
X_hebb_0_6  iwrite_0_6  inp_col_6  v_post_0  vcm vdd vss  hebbian_mult
X_hebb_0_7  iwrite_0_7  inp_col_7  v_post_0  vcm vdd vss  hebbian_mult
X_hebb_0_8  iwrite_0_8  inp_col_8  v_post_0  vcm vdd vss  hebbian_mult
X_hebb_0_9  iwrite_0_9  inp_col_9  v_post_0  vcm vdd vss  hebbian_mult
X_hebb_0_10  iwrite_0_10  inp_col_10  v_post_0  vcm vdd vss  hebbian_mult
X_hebb_0_11  iwrite_0_11  inp_col_11  v_post_0  vcm vdd vss  hebbian_mult
X_hebb_0_12  iwrite_0_12  inp_col_12  v_post_0  vcm vdd vss  hebbian_mult
X_hebb_0_13  iwrite_0_13  inp_col_13  v_post_0  vcm vdd vss  hebbian_mult
X_hebb_0_14  iwrite_0_14  inp_col_14  v_post_0  vcm vdd vss  hebbian_mult
X_hebb_0_15  iwrite_0_15  inp_col_15  v_post_0  vcm vdd vss  hebbian_mult

X_hebb_1_0  iwrite_1_0  inp_col_0  v_post_1  vcm vdd vss  hebbian_mult
X_hebb_1_1  iwrite_1_1  inp_col_1  v_post_1  vcm vdd vss  hebbian_mult
X_hebb_1_2  iwrite_1_2  inp_col_2  v_post_1  vcm vdd vss  hebbian_mult
X_hebb_1_3  iwrite_1_3  inp_col_3  v_post_1  vcm vdd vss  hebbian_mult
X_hebb_1_4  iwrite_1_4  inp_col_4  v_post_1  vcm vdd vss  hebbian_mult
X_hebb_1_5  iwrite_1_5  inp_col_5  v_post_1  vcm vdd vss  hebbian_mult
X_hebb_1_6  iwrite_1_6  inp_col_6  v_post_1  vcm vdd vss  hebbian_mult
X_hebb_1_7  iwrite_1_7  inp_col_7  v_post_1  vcm vdd vss  hebbian_mult
X_hebb_1_8  iwrite_1_8  inp_col_8  v_post_1  vcm vdd vss  hebbian_mult
X_hebb_1_9  iwrite_1_9  inp_col_9  v_post_1  vcm vdd vss  hebbian_mult
X_hebb_1_10  iwrite_1_10  inp_col_10  v_post_1  vcm vdd vss  hebbian_mult
X_hebb_1_11  iwrite_1_11  inp_col_11  v_post_1  vcm vdd vss  hebbian_mult
X_hebb_1_12  iwrite_1_12  inp_col_12  v_post_1  vcm vdd vss  hebbian_mult
X_hebb_1_13  iwrite_1_13  inp_col_13  v_post_1  vcm vdd vss  hebbian_mult
X_hebb_1_14  iwrite_1_14  inp_col_14  v_post_1  vcm vdd vss  hebbian_mult
X_hebb_1_15  iwrite_1_15  inp_col_15  v_post_1  vcm vdd vss  hebbian_mult

X_hebb_2_0  iwrite_2_0  inp_col_0  v_post_2  vcm vdd vss  hebbian_mult
X_hebb_2_1  iwrite_2_1  inp_col_1  v_post_2  vcm vdd vss  hebbian_mult
X_hebb_2_2  iwrite_2_2  inp_col_2  v_post_2  vcm vdd vss  hebbian_mult
X_hebb_2_3  iwrite_2_3  inp_col_3  v_post_2  vcm vdd vss  hebbian_mult
X_hebb_2_4  iwrite_2_4  inp_col_4  v_post_2  vcm vdd vss  hebbian_mult
X_hebb_2_5  iwrite_2_5  inp_col_5  v_post_2  vcm vdd vss  hebbian_mult
X_hebb_2_6  iwrite_2_6  inp_col_6  v_post_2  vcm vdd vss  hebbian_mult
X_hebb_2_7  iwrite_2_7  inp_col_7  v_post_2  vcm vdd vss  hebbian_mult
X_hebb_2_8  iwrite_2_8  inp_col_8  v_post_2  vcm vdd vss  hebbian_mult
X_hebb_2_9  iwrite_2_9  inp_col_9  v_post_2  vcm vdd vss  hebbian_mult
X_hebb_2_10  iwrite_2_10  inp_col_10  v_post_2  vcm vdd vss  hebbian_mult
X_hebb_2_11  iwrite_2_11  inp_col_11  v_post_2  vcm vdd vss  hebbian_mult
X_hebb_2_12  iwrite_2_12  inp_col_12  v_post_2  vcm vdd vss  hebbian_mult
X_hebb_2_13  iwrite_2_13  inp_col_13  v_post_2  vcm vdd vss  hebbian_mult
X_hebb_2_14  iwrite_2_14  inp_col_14  v_post_2  vcm vdd vss  hebbian_mult
X_hebb_2_15  iwrite_2_15  inp_col_15  v_post_2  vcm vdd vss  hebbian_mult

X_hebb_3_0  iwrite_3_0  inp_col_0  v_post_3  vcm vdd vss  hebbian_mult
X_hebb_3_1  iwrite_3_1  inp_col_1  v_post_3  vcm vdd vss  hebbian_mult
X_hebb_3_2  iwrite_3_2  inp_col_2  v_post_3  vcm vdd vss  hebbian_mult
X_hebb_3_3  iwrite_3_3  inp_col_3  v_post_3  vcm vdd vss  hebbian_mult
X_hebb_3_4  iwrite_3_4  inp_col_4  v_post_3  vcm vdd vss  hebbian_mult
X_hebb_3_5  iwrite_3_5  inp_col_5  v_post_3  vcm vdd vss  hebbian_mult
X_hebb_3_6  iwrite_3_6  inp_col_6  v_post_3  vcm vdd vss  hebbian_mult
X_hebb_3_7  iwrite_3_7  inp_col_7  v_post_3  vcm vdd vss  hebbian_mult
X_hebb_3_8  iwrite_3_8  inp_col_8  v_post_3  vcm vdd vss  hebbian_mult
X_hebb_3_9  iwrite_3_9  inp_col_9  v_post_3  vcm vdd vss  hebbian_mult
X_hebb_3_10  iwrite_3_10  inp_col_10  v_post_3  vcm vdd vss  hebbian_mult
X_hebb_3_11  iwrite_3_11  inp_col_11  v_post_3  vcm vdd vss  hebbian_mult
X_hebb_3_12  iwrite_3_12  inp_col_12  v_post_3  vcm vdd vss  hebbian_mult
X_hebb_3_13  iwrite_3_13  inp_col_13  v_post_3  vcm vdd vss  hebbian_mult
X_hebb_3_14  iwrite_3_14  inp_col_14  v_post_3  vcm vdd vss  hebbian_mult
X_hebb_3_15  iwrite_3_15  inp_col_15  v_post_3  vcm vdd vss  hebbian_mult

X_hebb_4_0  iwrite_4_0  inp_col_0  v_post_4  vcm vdd vss  hebbian_mult
X_hebb_4_1  iwrite_4_1  inp_col_1  v_post_4  vcm vdd vss  hebbian_mult
X_hebb_4_2  iwrite_4_2  inp_col_2  v_post_4  vcm vdd vss  hebbian_mult
X_hebb_4_3  iwrite_4_3  inp_col_3  v_post_4  vcm vdd vss  hebbian_mult
X_hebb_4_4  iwrite_4_4  inp_col_4  v_post_4  vcm vdd vss  hebbian_mult
X_hebb_4_5  iwrite_4_5  inp_col_5  v_post_4  vcm vdd vss  hebbian_mult
X_hebb_4_6  iwrite_4_6  inp_col_6  v_post_4  vcm vdd vss  hebbian_mult
X_hebb_4_7  iwrite_4_7  inp_col_7  v_post_4  vcm vdd vss  hebbian_mult
X_hebb_4_8  iwrite_4_8  inp_col_8  v_post_4  vcm vdd vss  hebbian_mult
X_hebb_4_9  iwrite_4_9  inp_col_9  v_post_4  vcm vdd vss  hebbian_mult
X_hebb_4_10  iwrite_4_10  inp_col_10  v_post_4  vcm vdd vss  hebbian_mult
X_hebb_4_11  iwrite_4_11  inp_col_11  v_post_4  vcm vdd vss  hebbian_mult
X_hebb_4_12  iwrite_4_12  inp_col_12  v_post_4  vcm vdd vss  hebbian_mult
X_hebb_4_13  iwrite_4_13  inp_col_13  v_post_4  vcm vdd vss  hebbian_mult
X_hebb_4_14  iwrite_4_14  inp_col_14  v_post_4  vcm vdd vss  hebbian_mult
X_hebb_4_15  iwrite_4_15  inp_col_15  v_post_4  vcm vdd vss  hebbian_mult

X_hebb_5_0  iwrite_5_0  inp_col_0  v_post_5  vcm vdd vss  hebbian_mult
X_hebb_5_1  iwrite_5_1  inp_col_1  v_post_5  vcm vdd vss  hebbian_mult
X_hebb_5_2  iwrite_5_2  inp_col_2  v_post_5  vcm vdd vss  hebbian_mult
X_hebb_5_3  iwrite_5_3  inp_col_3  v_post_5  vcm vdd vss  hebbian_mult
X_hebb_5_4  iwrite_5_4  inp_col_4  v_post_5  vcm vdd vss  hebbian_mult
X_hebb_5_5  iwrite_5_5  inp_col_5  v_post_5  vcm vdd vss  hebbian_mult
X_hebb_5_6  iwrite_5_6  inp_col_6  v_post_5  vcm vdd vss  hebbian_mult
X_hebb_5_7  iwrite_5_7  inp_col_7  v_post_5  vcm vdd vss  hebbian_mult
X_hebb_5_8  iwrite_5_8  inp_col_8  v_post_5  vcm vdd vss  hebbian_mult
X_hebb_5_9  iwrite_5_9  inp_col_9  v_post_5  vcm vdd vss  hebbian_mult
X_hebb_5_10  iwrite_5_10  inp_col_10  v_post_5  vcm vdd vss  hebbian_mult
X_hebb_5_11  iwrite_5_11  inp_col_11  v_post_5  vcm vdd vss  hebbian_mult
X_hebb_5_12  iwrite_5_12  inp_col_12  v_post_5  vcm vdd vss  hebbian_mult
X_hebb_5_13  iwrite_5_13  inp_col_13  v_post_5  vcm vdd vss  hebbian_mult
X_hebb_5_14  iwrite_5_14  inp_col_14  v_post_5  vcm vdd vss  hebbian_mult
X_hebb_5_15  iwrite_5_15  inp_col_15  v_post_5  vcm vdd vss  hebbian_mult

X_hebb_6_0  iwrite_6_0  inp_col_0  v_post_6  vcm vdd vss  hebbian_mult
X_hebb_6_1  iwrite_6_1  inp_col_1  v_post_6  vcm vdd vss  hebbian_mult
X_hebb_6_2  iwrite_6_2  inp_col_2  v_post_6  vcm vdd vss  hebbian_mult
X_hebb_6_3  iwrite_6_3  inp_col_3  v_post_6  vcm vdd vss  hebbian_mult
X_hebb_6_4  iwrite_6_4  inp_col_4  v_post_6  vcm vdd vss  hebbian_mult
X_hebb_6_5  iwrite_6_5  inp_col_5  v_post_6  vcm vdd vss  hebbian_mult
X_hebb_6_6  iwrite_6_6  inp_col_6  v_post_6  vcm vdd vss  hebbian_mult
X_hebb_6_7  iwrite_6_7  inp_col_7  v_post_6  vcm vdd vss  hebbian_mult
X_hebb_6_8  iwrite_6_8  inp_col_8  v_post_6  vcm vdd vss  hebbian_mult
X_hebb_6_9  iwrite_6_9  inp_col_9  v_post_6  vcm vdd vss  hebbian_mult
X_hebb_6_10  iwrite_6_10  inp_col_10  v_post_6  vcm vdd vss  hebbian_mult
X_hebb_6_11  iwrite_6_11  inp_col_11  v_post_6  vcm vdd vss  hebbian_mult
X_hebb_6_12  iwrite_6_12  inp_col_12  v_post_6  vcm vdd vss  hebbian_mult
X_hebb_6_13  iwrite_6_13  inp_col_13  v_post_6  vcm vdd vss  hebbian_mult
X_hebb_6_14  iwrite_6_14  inp_col_14  v_post_6  vcm vdd vss  hebbian_mult
X_hebb_6_15  iwrite_6_15  inp_col_15  v_post_6  vcm vdd vss  hebbian_mult

X_hebb_7_0  iwrite_7_0  inp_col_0  v_post_7  vcm vdd vss  hebbian_mult
X_hebb_7_1  iwrite_7_1  inp_col_1  v_post_7  vcm vdd vss  hebbian_mult
X_hebb_7_2  iwrite_7_2  inp_col_2  v_post_7  vcm vdd vss  hebbian_mult
X_hebb_7_3  iwrite_7_3  inp_col_3  v_post_7  vcm vdd vss  hebbian_mult
X_hebb_7_4  iwrite_7_4  inp_col_4  v_post_7  vcm vdd vss  hebbian_mult
X_hebb_7_5  iwrite_7_5  inp_col_5  v_post_7  vcm vdd vss  hebbian_mult
X_hebb_7_6  iwrite_7_6  inp_col_6  v_post_7  vcm vdd vss  hebbian_mult
X_hebb_7_7  iwrite_7_7  inp_col_7  v_post_7  vcm vdd vss  hebbian_mult
X_hebb_7_8  iwrite_7_8  inp_col_8  v_post_7  vcm vdd vss  hebbian_mult
X_hebb_7_9  iwrite_7_9  inp_col_9  v_post_7  vcm vdd vss  hebbian_mult
X_hebb_7_10  iwrite_7_10  inp_col_10  v_post_7  vcm vdd vss  hebbian_mult
X_hebb_7_11  iwrite_7_11  inp_col_11  v_post_7  vcm vdd vss  hebbian_mult
X_hebb_7_12  iwrite_7_12  inp_col_12  v_post_7  vcm vdd vss  hebbian_mult
X_hebb_7_13  iwrite_7_13  inp_col_13  v_post_7  vcm vdd vss  hebbian_mult
X_hebb_7_14  iwrite_7_14  inp_col_14  v_post_7  vcm vdd vss  hebbian_mult
X_hebb_7_15  iwrite_7_15  inp_col_15  v_post_7  vcm vdd vss  hebbian_mult

X_hebb_8_0  iwrite_8_0  inp_col_0  v_post_8  vcm vdd vss  hebbian_mult
X_hebb_8_1  iwrite_8_1  inp_col_1  v_post_8  vcm vdd vss  hebbian_mult
X_hebb_8_2  iwrite_8_2  inp_col_2  v_post_8  vcm vdd vss  hebbian_mult
X_hebb_8_3  iwrite_8_3  inp_col_3  v_post_8  vcm vdd vss  hebbian_mult
X_hebb_8_4  iwrite_8_4  inp_col_4  v_post_8  vcm vdd vss  hebbian_mult
X_hebb_8_5  iwrite_8_5  inp_col_5  v_post_8  vcm vdd vss  hebbian_mult
X_hebb_8_6  iwrite_8_6  inp_col_6  v_post_8  vcm vdd vss  hebbian_mult
X_hebb_8_7  iwrite_8_7  inp_col_7  v_post_8  vcm vdd vss  hebbian_mult
X_hebb_8_8  iwrite_8_8  inp_col_8  v_post_8  vcm vdd vss  hebbian_mult
X_hebb_8_9  iwrite_8_9  inp_col_9  v_post_8  vcm vdd vss  hebbian_mult
X_hebb_8_10  iwrite_8_10  inp_col_10  v_post_8  vcm vdd vss  hebbian_mult
X_hebb_8_11  iwrite_8_11  inp_col_11  v_post_8  vcm vdd vss  hebbian_mult
X_hebb_8_12  iwrite_8_12  inp_col_12  v_post_8  vcm vdd vss  hebbian_mult
X_hebb_8_13  iwrite_8_13  inp_col_13  v_post_8  vcm vdd vss  hebbian_mult
X_hebb_8_14  iwrite_8_14  inp_col_14  v_post_8  vcm vdd vss  hebbian_mult
X_hebb_8_15  iwrite_8_15  inp_col_15  v_post_8  vcm vdd vss  hebbian_mult

X_hebb_9_0  iwrite_9_0  inp_col_0  v_post_9  vcm vdd vss  hebbian_mult
X_hebb_9_1  iwrite_9_1  inp_col_1  v_post_9  vcm vdd vss  hebbian_mult
X_hebb_9_2  iwrite_9_2  inp_col_2  v_post_9  vcm vdd vss  hebbian_mult
X_hebb_9_3  iwrite_9_3  inp_col_3  v_post_9  vcm vdd vss  hebbian_mult
X_hebb_9_4  iwrite_9_4  inp_col_4  v_post_9  vcm vdd vss  hebbian_mult
X_hebb_9_5  iwrite_9_5  inp_col_5  v_post_9  vcm vdd vss  hebbian_mult
X_hebb_9_6  iwrite_9_6  inp_col_6  v_post_9  vcm vdd vss  hebbian_mult
X_hebb_9_7  iwrite_9_7  inp_col_7  v_post_9  vcm vdd vss  hebbian_mult
X_hebb_9_8  iwrite_9_8  inp_col_8  v_post_9  vcm vdd vss  hebbian_mult
X_hebb_9_9  iwrite_9_9  inp_col_9  v_post_9  vcm vdd vss  hebbian_mult
X_hebb_9_10  iwrite_9_10  inp_col_10  v_post_9  vcm vdd vss  hebbian_mult
X_hebb_9_11  iwrite_9_11  inp_col_11  v_post_9  vcm vdd vss  hebbian_mult
X_hebb_9_12  iwrite_9_12  inp_col_12  v_post_9  vcm vdd vss  hebbian_mult
X_hebb_9_13  iwrite_9_13  inp_col_13  v_post_9  vcm vdd vss  hebbian_mult
X_hebb_9_14  iwrite_9_14  inp_col_14  v_post_9  vcm vdd vss  hebbian_mult
X_hebb_9_15  iwrite_9_15  inp_col_15  v_post_9  vcm vdd vss  hebbian_mult

X_hebb_10_0  iwrite_10_0  inp_col_0  v_post_10  vcm vdd vss  hebbian_mult
X_hebb_10_1  iwrite_10_1  inp_col_1  v_post_10  vcm vdd vss  hebbian_mult
X_hebb_10_2  iwrite_10_2  inp_col_2  v_post_10  vcm vdd vss  hebbian_mult
X_hebb_10_3  iwrite_10_3  inp_col_3  v_post_10  vcm vdd vss  hebbian_mult
X_hebb_10_4  iwrite_10_4  inp_col_4  v_post_10  vcm vdd vss  hebbian_mult
X_hebb_10_5  iwrite_10_5  inp_col_5  v_post_10  vcm vdd vss  hebbian_mult
X_hebb_10_6  iwrite_10_6  inp_col_6  v_post_10  vcm vdd vss  hebbian_mult
X_hebb_10_7  iwrite_10_7  inp_col_7  v_post_10  vcm vdd vss  hebbian_mult
X_hebb_10_8  iwrite_10_8  inp_col_8  v_post_10  vcm vdd vss  hebbian_mult
X_hebb_10_9  iwrite_10_9  inp_col_9  v_post_10  vcm vdd vss  hebbian_mult
X_hebb_10_10  iwrite_10_10  inp_col_10  v_post_10  vcm vdd vss  hebbian_mult
X_hebb_10_11  iwrite_10_11  inp_col_11  v_post_10  vcm vdd vss  hebbian_mult
X_hebb_10_12  iwrite_10_12  inp_col_12  v_post_10  vcm vdd vss  hebbian_mult
X_hebb_10_13  iwrite_10_13  inp_col_13  v_post_10  vcm vdd vss  hebbian_mult
X_hebb_10_14  iwrite_10_14  inp_col_14  v_post_10  vcm vdd vss  hebbian_mult
X_hebb_10_15  iwrite_10_15  inp_col_15  v_post_10  vcm vdd vss  hebbian_mult

X_hebb_11_0  iwrite_11_0  inp_col_0  v_post_11  vcm vdd vss  hebbian_mult
X_hebb_11_1  iwrite_11_1  inp_col_1  v_post_11  vcm vdd vss  hebbian_mult
X_hebb_11_2  iwrite_11_2  inp_col_2  v_post_11  vcm vdd vss  hebbian_mult
X_hebb_11_3  iwrite_11_3  inp_col_3  v_post_11  vcm vdd vss  hebbian_mult
X_hebb_11_4  iwrite_11_4  inp_col_4  v_post_11  vcm vdd vss  hebbian_mult
X_hebb_11_5  iwrite_11_5  inp_col_5  v_post_11  vcm vdd vss  hebbian_mult
X_hebb_11_6  iwrite_11_6  inp_col_6  v_post_11  vcm vdd vss  hebbian_mult
X_hebb_11_7  iwrite_11_7  inp_col_7  v_post_11  vcm vdd vss  hebbian_mult
X_hebb_11_8  iwrite_11_8  inp_col_8  v_post_11  vcm vdd vss  hebbian_mult
X_hebb_11_9  iwrite_11_9  inp_col_9  v_post_11  vcm vdd vss  hebbian_mult
X_hebb_11_10  iwrite_11_10  inp_col_10  v_post_11  vcm vdd vss  hebbian_mult
X_hebb_11_11  iwrite_11_11  inp_col_11  v_post_11  vcm vdd vss  hebbian_mult
X_hebb_11_12  iwrite_11_12  inp_col_12  v_post_11  vcm vdd vss  hebbian_mult
X_hebb_11_13  iwrite_11_13  inp_col_13  v_post_11  vcm vdd vss  hebbian_mult
X_hebb_11_14  iwrite_11_14  inp_col_14  v_post_11  vcm vdd vss  hebbian_mult
X_hebb_11_15  iwrite_11_15  inp_col_15  v_post_11  vcm vdd vss  hebbian_mult

X_hebb_12_0  iwrite_12_0  inp_col_0  v_post_12  vcm vdd vss  hebbian_mult
X_hebb_12_1  iwrite_12_1  inp_col_1  v_post_12  vcm vdd vss  hebbian_mult
X_hebb_12_2  iwrite_12_2  inp_col_2  v_post_12  vcm vdd vss  hebbian_mult
X_hebb_12_3  iwrite_12_3  inp_col_3  v_post_12  vcm vdd vss  hebbian_mult
X_hebb_12_4  iwrite_12_4  inp_col_4  v_post_12  vcm vdd vss  hebbian_mult
X_hebb_12_5  iwrite_12_5  inp_col_5  v_post_12  vcm vdd vss  hebbian_mult
X_hebb_12_6  iwrite_12_6  inp_col_6  v_post_12  vcm vdd vss  hebbian_mult
X_hebb_12_7  iwrite_12_7  inp_col_7  v_post_12  vcm vdd vss  hebbian_mult
X_hebb_12_8  iwrite_12_8  inp_col_8  v_post_12  vcm vdd vss  hebbian_mult
X_hebb_12_9  iwrite_12_9  inp_col_9  v_post_12  vcm vdd vss  hebbian_mult
X_hebb_12_10  iwrite_12_10  inp_col_10  v_post_12  vcm vdd vss  hebbian_mult
X_hebb_12_11  iwrite_12_11  inp_col_11  v_post_12  vcm vdd vss  hebbian_mult
X_hebb_12_12  iwrite_12_12  inp_col_12  v_post_12  vcm vdd vss  hebbian_mult
X_hebb_12_13  iwrite_12_13  inp_col_13  v_post_12  vcm vdd vss  hebbian_mult
X_hebb_12_14  iwrite_12_14  inp_col_14  v_post_12  vcm vdd vss  hebbian_mult
X_hebb_12_15  iwrite_12_15  inp_col_15  v_post_12  vcm vdd vss  hebbian_mult

X_hebb_13_0  iwrite_13_0  inp_col_0  v_post_13  vcm vdd vss  hebbian_mult
X_hebb_13_1  iwrite_13_1  inp_col_1  v_post_13  vcm vdd vss  hebbian_mult
X_hebb_13_2  iwrite_13_2  inp_col_2  v_post_13  vcm vdd vss  hebbian_mult
X_hebb_13_3  iwrite_13_3  inp_col_3  v_post_13  vcm vdd vss  hebbian_mult
X_hebb_13_4  iwrite_13_4  inp_col_4  v_post_13  vcm vdd vss  hebbian_mult
X_hebb_13_5  iwrite_13_5  inp_col_5  v_post_13  vcm vdd vss  hebbian_mult
X_hebb_13_6  iwrite_13_6  inp_col_6  v_post_13  vcm vdd vss  hebbian_mult
X_hebb_13_7  iwrite_13_7  inp_col_7  v_post_13  vcm vdd vss  hebbian_mult
X_hebb_13_8  iwrite_13_8  inp_col_8  v_post_13  vcm vdd vss  hebbian_mult
X_hebb_13_9  iwrite_13_9  inp_col_9  v_post_13  vcm vdd vss  hebbian_mult
X_hebb_13_10  iwrite_13_10  inp_col_10  v_post_13  vcm vdd vss  hebbian_mult
X_hebb_13_11  iwrite_13_11  inp_col_11  v_post_13  vcm vdd vss  hebbian_mult
X_hebb_13_12  iwrite_13_12  inp_col_12  v_post_13  vcm vdd vss  hebbian_mult
X_hebb_13_13  iwrite_13_13  inp_col_13  v_post_13  vcm vdd vss  hebbian_mult
X_hebb_13_14  iwrite_13_14  inp_col_14  v_post_13  vcm vdd vss  hebbian_mult
X_hebb_13_15  iwrite_13_15  inp_col_15  v_post_13  vcm vdd vss  hebbian_mult

X_hebb_14_0  iwrite_14_0  inp_col_0  v_post_14  vcm vdd vss  hebbian_mult
X_hebb_14_1  iwrite_14_1  inp_col_1  v_post_14  vcm vdd vss  hebbian_mult
X_hebb_14_2  iwrite_14_2  inp_col_2  v_post_14  vcm vdd vss  hebbian_mult
X_hebb_14_3  iwrite_14_3  inp_col_3  v_post_14  vcm vdd vss  hebbian_mult
X_hebb_14_4  iwrite_14_4  inp_col_4  v_post_14  vcm vdd vss  hebbian_mult
X_hebb_14_5  iwrite_14_5  inp_col_5  v_post_14  vcm vdd vss  hebbian_mult
X_hebb_14_6  iwrite_14_6  inp_col_6  v_post_14  vcm vdd vss  hebbian_mult
X_hebb_14_7  iwrite_14_7  inp_col_7  v_post_14  vcm vdd vss  hebbian_mult
X_hebb_14_8  iwrite_14_8  inp_col_8  v_post_14  vcm vdd vss  hebbian_mult
X_hebb_14_9  iwrite_14_9  inp_col_9  v_post_14  vcm vdd vss  hebbian_mult
X_hebb_14_10  iwrite_14_10  inp_col_10  v_post_14  vcm vdd vss  hebbian_mult
X_hebb_14_11  iwrite_14_11  inp_col_11  v_post_14  vcm vdd vss  hebbian_mult
X_hebb_14_12  iwrite_14_12  inp_col_12  v_post_14  vcm vdd vss  hebbian_mult
X_hebb_14_13  iwrite_14_13  inp_col_13  v_post_14  vcm vdd vss  hebbian_mult
X_hebb_14_14  iwrite_14_14  inp_col_14  v_post_14  vcm vdd vss  hebbian_mult
X_hebb_14_15  iwrite_14_15  inp_col_15  v_post_14  vcm vdd vss  hebbian_mult

X_hebb_15_0  iwrite_15_0  inp_col_0  v_post_15  vcm vdd vss  hebbian_mult
X_hebb_15_1  iwrite_15_1  inp_col_1  v_post_15  vcm vdd vss  hebbian_mult
X_hebb_15_2  iwrite_15_2  inp_col_2  v_post_15  vcm vdd vss  hebbian_mult
X_hebb_15_3  iwrite_15_3  inp_col_3  v_post_15  vcm vdd vss  hebbian_mult
X_hebb_15_4  iwrite_15_4  inp_col_4  v_post_15  vcm vdd vss  hebbian_mult
X_hebb_15_5  iwrite_15_5  inp_col_5  v_post_15  vcm vdd vss  hebbian_mult
X_hebb_15_6  iwrite_15_6  inp_col_6  v_post_15  vcm vdd vss  hebbian_mult
X_hebb_15_7  iwrite_15_7  inp_col_7  v_post_15  vcm vdd vss  hebbian_mult
X_hebb_15_8  iwrite_15_8  inp_col_8  v_post_15  vcm vdd vss  hebbian_mult
X_hebb_15_9  iwrite_15_9  inp_col_9  v_post_15  vcm vdd vss  hebbian_mult
X_hebb_15_10  iwrite_15_10  inp_col_10  v_post_15  vcm vdd vss  hebbian_mult
X_hebb_15_11  iwrite_15_11  inp_col_11  v_post_15  vcm vdd vss  hebbian_mult
X_hebb_15_12  iwrite_15_12  inp_col_12  v_post_15  vcm vdd vss  hebbian_mult
X_hebb_15_13  iwrite_15_13  inp_col_13  v_post_15  vcm vdd vss  hebbian_mult
X_hebb_15_14  iwrite_15_14  inp_col_14  v_post_15  vcm vdd vss  hebbian_mult
X_hebb_15_15  iwrite_15_15  inp_col_15  v_post_15  vcm vdd vss  hebbian_mult

.ends pcn_array_16x16
