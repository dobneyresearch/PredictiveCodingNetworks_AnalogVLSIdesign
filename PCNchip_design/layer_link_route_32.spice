* Generated by gen_array.py — DO NOT EDIT by hand.
* Regenerate: python3 gen_array.py --routing 32
* Routing layer link: 32 ascending SFs + 32×32 routing matrix.
* Routing cells: 1024 XMPRED + 1024 Cw_route + 1024 MN4_r + 1024 hebbian_mult
*
* See pred_code_networks.md §42 for design rationale.

.subckt layer_link_route_32
+ iout_lower_0  iout_lower_1  iout_lower_2  iout_lower_3  iout_lower_4  iout_lower_5  iout_lower_6  iout_lower_7  iout_lower_8  iout_lower_9  iout_lower_10  iout_lower_11  iout_lower_12  iout_lower_13  iout_lower_14  iout_lower_15  iout_lower_16  iout_lower_17  iout_lower_18  iout_lower_19  iout_lower_20  iout_lower_21  iout_lower_22  iout_lower_23  iout_lower_24  iout_lower_25  iout_lower_26  iout_lower_27  iout_lower_28  iout_lower_29  iout_lower_30  iout_lower_31
+ inp_upper_0  inp_upper_1  inp_upper_2  inp_upper_3  inp_upper_4  inp_upper_5  inp_upper_6  inp_upper_7  inp_upper_8  inp_upper_9  inp_upper_10  inp_upper_11  inp_upper_12  inp_upper_13  inp_upper_14  inp_upper_15  inp_upper_16  inp_upper_17  inp_upper_18  inp_upper_19  inp_upper_20  inp_upper_21  inp_upper_22  inp_upper_23  inp_upper_24  inp_upper_25  inp_upper_26  inp_upper_27  inp_upper_28  inp_upper_29  inp_upper_30  inp_upper_31
+ i_pred_0  i_pred_1  i_pred_2  i_pred_3  i_pred_4  i_pred_5  i_pred_6  i_pred_7  i_pred_8  i_pred_9  i_pred_10  i_pred_11  i_pred_12  i_pred_13  i_pred_14  i_pred_15  i_pred_16  i_pred_17  i_pred_18  i_pred_19  i_pred_20  i_pred_21  i_pred_22  i_pred_23  i_pred_24  i_pred_25  i_pred_26  i_pred_27  i_pred_28  i_pred_29  i_pred_30  i_pred_31
+ iout_upper_0  iout_upper_1  iout_upper_2  iout_upper_3  iout_upper_4  iout_upper_5  iout_upper_6  iout_upper_7  iout_upper_8  iout_upper_9  iout_upper_10  iout_upper_11  iout_upper_12  iout_upper_13  iout_upper_14  iout_upper_15  iout_upper_16  iout_upper_17  iout_upper_18  iout_upper_19  iout_upper_20  iout_upper_21  iout_upper_22  iout_upper_23  iout_upper_24  iout_upper_25  iout_upper_26  iout_upper_27  iout_upper_28  iout_upper_29  iout_upper_30  iout_upper_31
+ ierr_dig_0  ierr_dig_1  ierr_dig_2  ierr_dig_3  ierr_dig_4  ierr_dig_5  ierr_dig_6  ierr_dig_7  ierr_dig_8  ierr_dig_9  ierr_dig_10  ierr_dig_11  ierr_dig_12  ierr_dig_13  ierr_dig_14  ierr_dig_15  ierr_dig_16  ierr_dig_17  ierr_dig_18  ierr_dig_19  ierr_dig_20  ierr_dig_21  ierr_dig_22  ierr_dig_23  ierr_dig_24  ierr_dig_25  ierr_dig_26  ierr_dig_27  ierr_dig_28  ierr_dig_29  ierr_dig_30  ierr_dig_31
+ we_route
+ vcm_route vcm_upper vcm_iout vbias_n vdd vss

* ──────────────────────────────────────────────────────────────────────────
* ASCENDING PATH: 32 PMOS source followers  iout_lower_r → inp_upper_r
* V(inp_upper) = V(iout_lower) + |Vgs_P| ≈ +0.65V (§71 PMOS SF fix)
* ──────────────────────────────────────────────────────────────────────────
* Row 0
XMSF_0   n_sf_d_0  iout_lower_0  inp_upper_0  vdd   sky130_fd_pr__pfet_01v8  w=4  l=0.5
XMTAIL_0  n_sf_d_0  vbias_n  vss  vss   sky130_fd_pr__nfet_01v8  w=2  l=1
* Row 1
XMSF_1   n_sf_d_1  iout_lower_1  inp_upper_1  vdd   sky130_fd_pr__pfet_01v8  w=4  l=0.5
XMTAIL_1  n_sf_d_1  vbias_n  vss  vss   sky130_fd_pr__nfet_01v8  w=2  l=1
* Row 2
XMSF_2   n_sf_d_2  iout_lower_2  inp_upper_2  vdd   sky130_fd_pr__pfet_01v8  w=4  l=0.5
XMTAIL_2  n_sf_d_2  vbias_n  vss  vss   sky130_fd_pr__nfet_01v8  w=2  l=1
* Row 3
XMSF_3   n_sf_d_3  iout_lower_3  inp_upper_3  vdd   sky130_fd_pr__pfet_01v8  w=4  l=0.5
XMTAIL_3  n_sf_d_3  vbias_n  vss  vss   sky130_fd_pr__nfet_01v8  w=2  l=1
* Row 4
XMSF_4   n_sf_d_4  iout_lower_4  inp_upper_4  vdd   sky130_fd_pr__pfet_01v8  w=4  l=0.5
XMTAIL_4  n_sf_d_4  vbias_n  vss  vss   sky130_fd_pr__nfet_01v8  w=2  l=1
* Row 5
XMSF_5   n_sf_d_5  iout_lower_5  inp_upper_5  vdd   sky130_fd_pr__pfet_01v8  w=4  l=0.5
XMTAIL_5  n_sf_d_5  vbias_n  vss  vss   sky130_fd_pr__nfet_01v8  w=2  l=1
* Row 6
XMSF_6   n_sf_d_6  iout_lower_6  inp_upper_6  vdd   sky130_fd_pr__pfet_01v8  w=4  l=0.5
XMTAIL_6  n_sf_d_6  vbias_n  vss  vss   sky130_fd_pr__nfet_01v8  w=2  l=1
* Row 7
XMSF_7   n_sf_d_7  iout_lower_7  inp_upper_7  vdd   sky130_fd_pr__pfet_01v8  w=4  l=0.5
XMTAIL_7  n_sf_d_7  vbias_n  vss  vss   sky130_fd_pr__nfet_01v8  w=2  l=1
* Row 8
XMSF_8   n_sf_d_8  iout_lower_8  inp_upper_8  vdd   sky130_fd_pr__pfet_01v8  w=4  l=0.5
XMTAIL_8  n_sf_d_8  vbias_n  vss  vss   sky130_fd_pr__nfet_01v8  w=2  l=1
* Row 9
XMSF_9   n_sf_d_9  iout_lower_9  inp_upper_9  vdd   sky130_fd_pr__pfet_01v8  w=4  l=0.5
XMTAIL_9  n_sf_d_9  vbias_n  vss  vss   sky130_fd_pr__nfet_01v8  w=2  l=1
* Row 10
XMSF_10   n_sf_d_10  iout_lower_10  inp_upper_10  vdd   sky130_fd_pr__pfet_01v8  w=4  l=0.5
XMTAIL_10  n_sf_d_10  vbias_n  vss  vss   sky130_fd_pr__nfet_01v8  w=2  l=1
* Row 11
XMSF_11   n_sf_d_11  iout_lower_11  inp_upper_11  vdd   sky130_fd_pr__pfet_01v8  w=4  l=0.5
XMTAIL_11  n_sf_d_11  vbias_n  vss  vss   sky130_fd_pr__nfet_01v8  w=2  l=1
* Row 12
XMSF_12   n_sf_d_12  iout_lower_12  inp_upper_12  vdd   sky130_fd_pr__pfet_01v8  w=4  l=0.5
XMTAIL_12  n_sf_d_12  vbias_n  vss  vss   sky130_fd_pr__nfet_01v8  w=2  l=1
* Row 13
XMSF_13   n_sf_d_13  iout_lower_13  inp_upper_13  vdd   sky130_fd_pr__pfet_01v8  w=4  l=0.5
XMTAIL_13  n_sf_d_13  vbias_n  vss  vss   sky130_fd_pr__nfet_01v8  w=2  l=1
* Row 14
XMSF_14   n_sf_d_14  iout_lower_14  inp_upper_14  vdd   sky130_fd_pr__pfet_01v8  w=4  l=0.5
XMTAIL_14  n_sf_d_14  vbias_n  vss  vss   sky130_fd_pr__nfet_01v8  w=2  l=1
* Row 15
XMSF_15   n_sf_d_15  iout_lower_15  inp_upper_15  vdd   sky130_fd_pr__pfet_01v8  w=4  l=0.5
XMTAIL_15  n_sf_d_15  vbias_n  vss  vss   sky130_fd_pr__nfet_01v8  w=2  l=1
* Row 16
XMSF_16   n_sf_d_16  iout_lower_16  inp_upper_16  vdd   sky130_fd_pr__pfet_01v8  w=4  l=0.5
XMTAIL_16  n_sf_d_16  vbias_n  vss  vss   sky130_fd_pr__nfet_01v8  w=2  l=1
* Row 17
XMSF_17   n_sf_d_17  iout_lower_17  inp_upper_17  vdd   sky130_fd_pr__pfet_01v8  w=4  l=0.5
XMTAIL_17  n_sf_d_17  vbias_n  vss  vss   sky130_fd_pr__nfet_01v8  w=2  l=1
* Row 18
XMSF_18   n_sf_d_18  iout_lower_18  inp_upper_18  vdd   sky130_fd_pr__pfet_01v8  w=4  l=0.5
XMTAIL_18  n_sf_d_18  vbias_n  vss  vss   sky130_fd_pr__nfet_01v8  w=2  l=1
* Row 19
XMSF_19   n_sf_d_19  iout_lower_19  inp_upper_19  vdd   sky130_fd_pr__pfet_01v8  w=4  l=0.5
XMTAIL_19  n_sf_d_19  vbias_n  vss  vss   sky130_fd_pr__nfet_01v8  w=2  l=1
* Row 20
XMSF_20   n_sf_d_20  iout_lower_20  inp_upper_20  vdd   sky130_fd_pr__pfet_01v8  w=4  l=0.5
XMTAIL_20  n_sf_d_20  vbias_n  vss  vss   sky130_fd_pr__nfet_01v8  w=2  l=1
* Row 21
XMSF_21   n_sf_d_21  iout_lower_21  inp_upper_21  vdd   sky130_fd_pr__pfet_01v8  w=4  l=0.5
XMTAIL_21  n_sf_d_21  vbias_n  vss  vss   sky130_fd_pr__nfet_01v8  w=2  l=1
* Row 22
XMSF_22   n_sf_d_22  iout_lower_22  inp_upper_22  vdd   sky130_fd_pr__pfet_01v8  w=4  l=0.5
XMTAIL_22  n_sf_d_22  vbias_n  vss  vss   sky130_fd_pr__nfet_01v8  w=2  l=1
* Row 23
XMSF_23   n_sf_d_23  iout_lower_23  inp_upper_23  vdd   sky130_fd_pr__pfet_01v8  w=4  l=0.5
XMTAIL_23  n_sf_d_23  vbias_n  vss  vss   sky130_fd_pr__nfet_01v8  w=2  l=1
* Row 24
XMSF_24   n_sf_d_24  iout_lower_24  inp_upper_24  vdd   sky130_fd_pr__pfet_01v8  w=4  l=0.5
XMTAIL_24  n_sf_d_24  vbias_n  vss  vss   sky130_fd_pr__nfet_01v8  w=2  l=1
* Row 25
XMSF_25   n_sf_d_25  iout_lower_25  inp_upper_25  vdd   sky130_fd_pr__pfet_01v8  w=4  l=0.5
XMTAIL_25  n_sf_d_25  vbias_n  vss  vss   sky130_fd_pr__nfet_01v8  w=2  l=1
* Row 26
XMSF_26   n_sf_d_26  iout_lower_26  inp_upper_26  vdd   sky130_fd_pr__pfet_01v8  w=4  l=0.5
XMTAIL_26  n_sf_d_26  vbias_n  vss  vss   sky130_fd_pr__nfet_01v8  w=2  l=1
* Row 27
XMSF_27   n_sf_d_27  iout_lower_27  inp_upper_27  vdd   sky130_fd_pr__pfet_01v8  w=4  l=0.5
XMTAIL_27  n_sf_d_27  vbias_n  vss  vss   sky130_fd_pr__nfet_01v8  w=2  l=1
* Row 28
XMSF_28   n_sf_d_28  iout_lower_28  inp_upper_28  vdd   sky130_fd_pr__pfet_01v8  w=4  l=0.5
XMTAIL_28  n_sf_d_28  vbias_n  vss  vss   sky130_fd_pr__nfet_01v8  w=2  l=1
* Row 29
XMSF_29   n_sf_d_29  iout_lower_29  inp_upper_29  vdd   sky130_fd_pr__pfet_01v8  w=4  l=0.5
XMTAIL_29  n_sf_d_29  vbias_n  vss  vss   sky130_fd_pr__nfet_01v8  w=2  l=1
* Row 30
XMSF_30   n_sf_d_30  iout_lower_30  inp_upper_30  vdd   sky130_fd_pr__pfet_01v8  w=4  l=0.5
XMTAIL_30  n_sf_d_30  vbias_n  vss  vss   sky130_fd_pr__nfet_01v8  w=2  l=1
* Row 31
XMSF_31   n_sf_d_31  iout_lower_31  inp_upper_31  vdd   sky130_fd_pr__pfet_01v8  w=4  l=0.5
XMTAIL_31  n_sf_d_31  vbias_n  vss  vss   sky130_fd_pr__nfet_01v8  w=2  l=1
* Reference PMOS SF: vcm_iout → vcm_upper (matched shift for inn_col; §72 fix)
XMSF_ref   n_sfref_d  vcm_iout  vcm_upper  vdd   sky130_fd_pr__pfet_01v8  w=4  l=0.5
XMTAIL_ref n_sfref_d  vbias_n  vss  vss   sky130_fd_pr__nfet_01v8  w=2  l=1

* ──────────────────────────────────────────────────────────────────────────
* DESCENDING ROUTING MATRIX: 32×32 = 1024 routing cells
*
* For each (dest=d, src=s):
*   XMPRED_r_d_s  — NMOS sinking from i_pred_d; gate=Vw_route_d_s
*   Cw_route_d_s  — 200fF routing weight capacitor (increase to 2p for
*                   10× slower topology timescale vs MAC weights)
*   MN4_r_d_s     — access transistor; gate=we_route
*   X_rhebb_d_s   — hebbian_mult: v_pre=inp_upper_s, vcm=vcm_route, v_post=ierr_dig_d
*                   updates Cw_route when source active AND dest has error
* ──────────────────────────────────────────────────────────────────────────

* ── Destination row 0 ── 32 source connections ──────────────────────────
XMPRED_r_0_0  i_pred_0  vw_route_0_0  vss  vss  sky130_fd_pr__nfet_01v8  w=4  l=0.35
Cw_route_0_0  vw_route_0_0  vss  200f
R_bleed_0_0  vw_route_0_0  vss  10000meg
XMN4_r_0_0  vw_route_0_0  we_route  iwrite_route_0_0  vss  sky130_fd_pr__nfet_01v8  w=0.5  l=0.5
X_rhebb_0_0  iwrite_route_0_0  inp_upper_0  ierr_dig_0  vcm_route  vdd vss  hebbian_mult
XMPRED_r_0_1  i_pred_0  vw_route_0_1  vss  vss  sky130_fd_pr__nfet_01v8  w=4  l=0.35
Cw_route_0_1  vw_route_0_1  vss  200f
R_bleed_0_1  vw_route_0_1  vss  10000meg
XMN4_r_0_1  vw_route_0_1  we_route  iwrite_route_0_1  vss  sky130_fd_pr__nfet_01v8  w=0.5  l=0.5
X_rhebb_0_1  iwrite_route_0_1  inp_upper_1  ierr_dig_0  vcm_route  vdd vss  hebbian_mult
XMPRED_r_0_2  i_pred_0  vw_route_0_2  vss  vss  sky130_fd_pr__nfet_01v8  w=4  l=0.35
Cw_route_0_2  vw_route_0_2  vss  200f
R_bleed_0_2  vw_route_0_2  vss  10000meg
XMN4_r_0_2  vw_route_0_2  we_route  iwrite_route_0_2  vss  sky130_fd_pr__nfet_01v8  w=0.5  l=0.5
X_rhebb_0_2  iwrite_route_0_2  inp_upper_2  ierr_dig_0  vcm_route  vdd vss  hebbian_mult
XMPRED_r_0_3  i_pred_0  vw_route_0_3  vss  vss  sky130_fd_pr__nfet_01v8  w=4  l=0.35
Cw_route_0_3  vw_route_0_3  vss  200f
R_bleed_0_3  vw_route_0_3  vss  10000meg
XMN4_r_0_3  vw_route_0_3  we_route  iwrite_route_0_3  vss  sky130_fd_pr__nfet_01v8  w=0.5  l=0.5
X_rhebb_0_3  iwrite_route_0_3  inp_upper_3  ierr_dig_0  vcm_route  vdd vss  hebbian_mult
XMPRED_r_0_4  i_pred_0  vw_route_0_4  vss  vss  sky130_fd_pr__nfet_01v8  w=4  l=0.35
Cw_route_0_4  vw_route_0_4  vss  200f
R_bleed_0_4  vw_route_0_4  vss  10000meg
XMN4_r_0_4  vw_route_0_4  we_route  iwrite_route_0_4  vss  sky130_fd_pr__nfet_01v8  w=0.5  l=0.5
X_rhebb_0_4  iwrite_route_0_4  inp_upper_4  ierr_dig_0  vcm_route  vdd vss  hebbian_mult
XMPRED_r_0_5  i_pred_0  vw_route_0_5  vss  vss  sky130_fd_pr__nfet_01v8  w=4  l=0.35
Cw_route_0_5  vw_route_0_5  vss  200f
R_bleed_0_5  vw_route_0_5  vss  10000meg
XMN4_r_0_5  vw_route_0_5  we_route  iwrite_route_0_5  vss  sky130_fd_pr__nfet_01v8  w=0.5  l=0.5
X_rhebb_0_5  iwrite_route_0_5  inp_upper_5  ierr_dig_0  vcm_route  vdd vss  hebbian_mult
XMPRED_r_0_6  i_pred_0  vw_route_0_6  vss  vss  sky130_fd_pr__nfet_01v8  w=4  l=0.35
Cw_route_0_6  vw_route_0_6  vss  200f
R_bleed_0_6  vw_route_0_6  vss  10000meg
XMN4_r_0_6  vw_route_0_6  we_route  iwrite_route_0_6  vss  sky130_fd_pr__nfet_01v8  w=0.5  l=0.5
X_rhebb_0_6  iwrite_route_0_6  inp_upper_6  ierr_dig_0  vcm_route  vdd vss  hebbian_mult
XMPRED_r_0_7  i_pred_0  vw_route_0_7  vss  vss  sky130_fd_pr__nfet_01v8  w=4  l=0.35
Cw_route_0_7  vw_route_0_7  vss  200f
R_bleed_0_7  vw_route_0_7  vss  10000meg
XMN4_r_0_7  vw_route_0_7  we_route  iwrite_route_0_7  vss  sky130_fd_pr__nfet_01v8  w=0.5  l=0.5
X_rhebb_0_7  iwrite_route_0_7  inp_upper_7  ierr_dig_0  vcm_route  vdd vss  hebbian_mult
XMPRED_r_0_8  i_pred_0  vw_route_0_8  vss  vss  sky130_fd_pr__nfet_01v8  w=4  l=0.35
Cw_route_0_8  vw_route_0_8  vss  200f
R_bleed_0_8  vw_route_0_8  vss  10000meg
XMN4_r_0_8  vw_route_0_8  we_route  iwrite_route_0_8  vss  sky130_fd_pr__nfet_01v8  w=0.5  l=0.5
X_rhebb_0_8  iwrite_route_0_8  inp_upper_8  ierr_dig_0  vcm_route  vdd vss  hebbian_mult
XMPRED_r_0_9  i_pred_0  vw_route_0_9  vss  vss  sky130_fd_pr__nfet_01v8  w=4  l=0.35
Cw_route_0_9  vw_route_0_9  vss  200f
R_bleed_0_9  vw_route_0_9  vss  10000meg
XMN4_r_0_9  vw_route_0_9  we_route  iwrite_route_0_9  vss  sky130_fd_pr__nfet_01v8  w=0.5  l=0.5
X_rhebb_0_9  iwrite_route_0_9  inp_upper_9  ierr_dig_0  vcm_route  vdd vss  hebbian_mult
XMPRED_r_0_10  i_pred_0  vw_route_0_10  vss  vss  sky130_fd_pr__nfet_01v8  w=4  l=0.35
Cw_route_0_10  vw_route_0_10  vss  200f
R_bleed_0_10  vw_route_0_10  vss  10000meg
XMN4_r_0_10  vw_route_0_10  we_route  iwrite_route_0_10  vss  sky130_fd_pr__nfet_01v8  w=0.5  l=0.5
X_rhebb_0_10  iwrite_route_0_10  inp_upper_10  ierr_dig_0  vcm_route  vdd vss  hebbian_mult
XMPRED_r_0_11  i_pred_0  vw_route_0_11  vss  vss  sky130_fd_pr__nfet_01v8  w=4  l=0.35
Cw_route_0_11  vw_route_0_11  vss  200f
R_bleed_0_11  vw_route_0_11  vss  10000meg
XMN4_r_0_11  vw_route_0_11  we_route  iwrite_route_0_11  vss  sky130_fd_pr__nfet_01v8  w=0.5  l=0.5
X_rhebb_0_11  iwrite_route_0_11  inp_upper_11  ierr_dig_0  vcm_route  vdd vss  hebbian_mult
XMPRED_r_0_12  i_pred_0  vw_route_0_12  vss  vss  sky130_fd_pr__nfet_01v8  w=4  l=0.35
Cw_route_0_12  vw_route_0_12  vss  200f
R_bleed_0_12  vw_route_0_12  vss  10000meg
XMN4_r_0_12  vw_route_0_12  we_route  iwrite_route_0_12  vss  sky130_fd_pr__nfet_01v8  w=0.5  l=0.5
X_rhebb_0_12  iwrite_route_0_12  inp_upper_12  ierr_dig_0  vcm_route  vdd vss  hebbian_mult
XMPRED_r_0_13  i_pred_0  vw_route_0_13  vss  vss  sky130_fd_pr__nfet_01v8  w=4  l=0.35
Cw_route_0_13  vw_route_0_13  vss  200f
R_bleed_0_13  vw_route_0_13  vss  10000meg
XMN4_r_0_13  vw_route_0_13  we_route  iwrite_route_0_13  vss  sky130_fd_pr__nfet_01v8  w=0.5  l=0.5
X_rhebb_0_13  iwrite_route_0_13  inp_upper_13  ierr_dig_0  vcm_route  vdd vss  hebbian_mult
XMPRED_r_0_14  i_pred_0  vw_route_0_14  vss  vss  sky130_fd_pr__nfet_01v8  w=4  l=0.35
Cw_route_0_14  vw_route_0_14  vss  200f
R_bleed_0_14  vw_route_0_14  vss  10000meg
XMN4_r_0_14  vw_route_0_14  we_route  iwrite_route_0_14  vss  sky130_fd_pr__nfet_01v8  w=0.5  l=0.5
X_rhebb_0_14  iwrite_route_0_14  inp_upper_14  ierr_dig_0  vcm_route  vdd vss  hebbian_mult
XMPRED_r_0_15  i_pred_0  vw_route_0_15  vss  vss  sky130_fd_pr__nfet_01v8  w=4  l=0.35
Cw_route_0_15  vw_route_0_15  vss  200f
R_bleed_0_15  vw_route_0_15  vss  10000meg
XMN4_r_0_15  vw_route_0_15  we_route  iwrite_route_0_15  vss  sky130_fd_pr__nfet_01v8  w=0.5  l=0.5
X_rhebb_0_15  iwrite_route_0_15  inp_upper_15  ierr_dig_0  vcm_route  vdd vss  hebbian_mult
XMPRED_r_0_16  i_pred_0  vw_route_0_16  vss  vss  sky130_fd_pr__nfet_01v8  w=4  l=0.35
Cw_route_0_16  vw_route_0_16  vss  200f
R_bleed_0_16  vw_route_0_16  vss  10000meg
XMN4_r_0_16  vw_route_0_16  we_route  iwrite_route_0_16  vss  sky130_fd_pr__nfet_01v8  w=0.5  l=0.5
X_rhebb_0_16  iwrite_route_0_16  inp_upper_16  ierr_dig_0  vcm_route  vdd vss  hebbian_mult
XMPRED_r_0_17  i_pred_0  vw_route_0_17  vss  vss  sky130_fd_pr__nfet_01v8  w=4  l=0.35
Cw_route_0_17  vw_route_0_17  vss  200f
R_bleed_0_17  vw_route_0_17  vss  10000meg
XMN4_r_0_17  vw_route_0_17  we_route  iwrite_route_0_17  vss  sky130_fd_pr__nfet_01v8  w=0.5  l=0.5
X_rhebb_0_17  iwrite_route_0_17  inp_upper_17  ierr_dig_0  vcm_route  vdd vss  hebbian_mult
XMPRED_r_0_18  i_pred_0  vw_route_0_18  vss  vss  sky130_fd_pr__nfet_01v8  w=4  l=0.35
Cw_route_0_18  vw_route_0_18  vss  200f
R_bleed_0_18  vw_route_0_18  vss  10000meg
XMN4_r_0_18  vw_route_0_18  we_route  iwrite_route_0_18  vss  sky130_fd_pr__nfet_01v8  w=0.5  l=0.5
X_rhebb_0_18  iwrite_route_0_18  inp_upper_18  ierr_dig_0  vcm_route  vdd vss  hebbian_mult
XMPRED_r_0_19  i_pred_0  vw_route_0_19  vss  vss  sky130_fd_pr__nfet_01v8  w=4  l=0.35
Cw_route_0_19  vw_route_0_19  vss  200f
R_bleed_0_19  vw_route_0_19  vss  10000meg
XMN4_r_0_19  vw_route_0_19  we_route  iwrite_route_0_19  vss  sky130_fd_pr__nfet_01v8  w=0.5  l=0.5
X_rhebb_0_19  iwrite_route_0_19  inp_upper_19  ierr_dig_0  vcm_route  vdd vss  hebbian_mult
XMPRED_r_0_20  i_pred_0  vw_route_0_20  vss  vss  sky130_fd_pr__nfet_01v8  w=4  l=0.35
Cw_route_0_20  vw_route_0_20  vss  200f
R_bleed_0_20  vw_route_0_20  vss  10000meg
XMN4_r_0_20  vw_route_0_20  we_route  iwrite_route_0_20  vss  sky130_fd_pr__nfet_01v8  w=0.5  l=0.5
X_rhebb_0_20  iwrite_route_0_20  inp_upper_20  ierr_dig_0  vcm_route  vdd vss  hebbian_mult
XMPRED_r_0_21  i_pred_0  vw_route_0_21  vss  vss  sky130_fd_pr__nfet_01v8  w=4  l=0.35
Cw_route_0_21  vw_route_0_21  vss  200f
R_bleed_0_21  vw_route_0_21  vss  10000meg
XMN4_r_0_21  vw_route_0_21  we_route  iwrite_route_0_21  vss  sky130_fd_pr__nfet_01v8  w=0.5  l=0.5
X_rhebb_0_21  iwrite_route_0_21  inp_upper_21  ierr_dig_0  vcm_route  vdd vss  hebbian_mult
XMPRED_r_0_22  i_pred_0  vw_route_0_22  vss  vss  sky130_fd_pr__nfet_01v8  w=4  l=0.35
Cw_route_0_22  vw_route_0_22  vss  200f
R_bleed_0_22  vw_route_0_22  vss  10000meg
XMN4_r_0_22  vw_route_0_22  we_route  iwrite_route_0_22  vss  sky130_fd_pr__nfet_01v8  w=0.5  l=0.5
X_rhebb_0_22  iwrite_route_0_22  inp_upper_22  ierr_dig_0  vcm_route  vdd vss  hebbian_mult
XMPRED_r_0_23  i_pred_0  vw_route_0_23  vss  vss  sky130_fd_pr__nfet_01v8  w=4  l=0.35
Cw_route_0_23  vw_route_0_23  vss  200f
R_bleed_0_23  vw_route_0_23  vss  10000meg
XMN4_r_0_23  vw_route_0_23  we_route  iwrite_route_0_23  vss  sky130_fd_pr__nfet_01v8  w=0.5  l=0.5
X_rhebb_0_23  iwrite_route_0_23  inp_upper_23  ierr_dig_0  vcm_route  vdd vss  hebbian_mult
XMPRED_r_0_24  i_pred_0  vw_route_0_24  vss  vss  sky130_fd_pr__nfet_01v8  w=4  l=0.35
Cw_route_0_24  vw_route_0_24  vss  200f
R_bleed_0_24  vw_route_0_24  vss  10000meg
XMN4_r_0_24  vw_route_0_24  we_route  iwrite_route_0_24  vss  sky130_fd_pr__nfet_01v8  w=0.5  l=0.5
X_rhebb_0_24  iwrite_route_0_24  inp_upper_24  ierr_dig_0  vcm_route  vdd vss  hebbian_mult
XMPRED_r_0_25  i_pred_0  vw_route_0_25  vss  vss  sky130_fd_pr__nfet_01v8  w=4  l=0.35
Cw_route_0_25  vw_route_0_25  vss  200f
R_bleed_0_25  vw_route_0_25  vss  10000meg
XMN4_r_0_25  vw_route_0_25  we_route  iwrite_route_0_25  vss  sky130_fd_pr__nfet_01v8  w=0.5  l=0.5
X_rhebb_0_25  iwrite_route_0_25  inp_upper_25  ierr_dig_0  vcm_route  vdd vss  hebbian_mult
XMPRED_r_0_26  i_pred_0  vw_route_0_26  vss  vss  sky130_fd_pr__nfet_01v8  w=4  l=0.35
Cw_route_0_26  vw_route_0_26  vss  200f
R_bleed_0_26  vw_route_0_26  vss  10000meg
XMN4_r_0_26  vw_route_0_26  we_route  iwrite_route_0_26  vss  sky130_fd_pr__nfet_01v8  w=0.5  l=0.5
X_rhebb_0_26  iwrite_route_0_26  inp_upper_26  ierr_dig_0  vcm_route  vdd vss  hebbian_mult
XMPRED_r_0_27  i_pred_0  vw_route_0_27  vss  vss  sky130_fd_pr__nfet_01v8  w=4  l=0.35
Cw_route_0_27  vw_route_0_27  vss  200f
R_bleed_0_27  vw_route_0_27  vss  10000meg
XMN4_r_0_27  vw_route_0_27  we_route  iwrite_route_0_27  vss  sky130_fd_pr__nfet_01v8  w=0.5  l=0.5
X_rhebb_0_27  iwrite_route_0_27  inp_upper_27  ierr_dig_0  vcm_route  vdd vss  hebbian_mult
XMPRED_r_0_28  i_pred_0  vw_route_0_28  vss  vss  sky130_fd_pr__nfet_01v8  w=4  l=0.35
Cw_route_0_28  vw_route_0_28  vss  200f
R_bleed_0_28  vw_route_0_28  vss  10000meg
XMN4_r_0_28  vw_route_0_28  we_route  iwrite_route_0_28  vss  sky130_fd_pr__nfet_01v8  w=0.5  l=0.5
X_rhebb_0_28  iwrite_route_0_28  inp_upper_28  ierr_dig_0  vcm_route  vdd vss  hebbian_mult
XMPRED_r_0_29  i_pred_0  vw_route_0_29  vss  vss  sky130_fd_pr__nfet_01v8  w=4  l=0.35
Cw_route_0_29  vw_route_0_29  vss  200f
R_bleed_0_29  vw_route_0_29  vss  10000meg
XMN4_r_0_29  vw_route_0_29  we_route  iwrite_route_0_29  vss  sky130_fd_pr__nfet_01v8  w=0.5  l=0.5
X_rhebb_0_29  iwrite_route_0_29  inp_upper_29  ierr_dig_0  vcm_route  vdd vss  hebbian_mult
XMPRED_r_0_30  i_pred_0  vw_route_0_30  vss  vss  sky130_fd_pr__nfet_01v8  w=4  l=0.35
Cw_route_0_30  vw_route_0_30  vss  200f
R_bleed_0_30  vw_route_0_30  vss  10000meg
XMN4_r_0_30  vw_route_0_30  we_route  iwrite_route_0_30  vss  sky130_fd_pr__nfet_01v8  w=0.5  l=0.5
X_rhebb_0_30  iwrite_route_0_30  inp_upper_30  ierr_dig_0  vcm_route  vdd vss  hebbian_mult
XMPRED_r_0_31  i_pred_0  vw_route_0_31  vss  vss  sky130_fd_pr__nfet_01v8  w=4  l=0.35
Cw_route_0_31  vw_route_0_31  vss  200f
R_bleed_0_31  vw_route_0_31  vss  10000meg
XMN4_r_0_31  vw_route_0_31  we_route  iwrite_route_0_31  vss  sky130_fd_pr__nfet_01v8  w=0.5  l=0.5
X_rhebb_0_31  iwrite_route_0_31  inp_upper_31  ierr_dig_0  vcm_route  vdd vss  hebbian_mult

* ── Destination row 1 ── 32 source connections ──────────────────────────
XMPRED_r_1_0  i_pred_1  vw_route_1_0  vss  vss  sky130_fd_pr__nfet_01v8  w=4  l=0.35
Cw_route_1_0  vw_route_1_0  vss  200f
R_bleed_1_0  vw_route_1_0  vss  10000meg
XMN4_r_1_0  vw_route_1_0  we_route  iwrite_route_1_0  vss  sky130_fd_pr__nfet_01v8  w=0.5  l=0.5
X_rhebb_1_0  iwrite_route_1_0  inp_upper_0  ierr_dig_1  vcm_route  vdd vss  hebbian_mult
XMPRED_r_1_1  i_pred_1  vw_route_1_1  vss  vss  sky130_fd_pr__nfet_01v8  w=4  l=0.35
Cw_route_1_1  vw_route_1_1  vss  200f
R_bleed_1_1  vw_route_1_1  vss  10000meg
XMN4_r_1_1  vw_route_1_1  we_route  iwrite_route_1_1  vss  sky130_fd_pr__nfet_01v8  w=0.5  l=0.5
X_rhebb_1_1  iwrite_route_1_1  inp_upper_1  ierr_dig_1  vcm_route  vdd vss  hebbian_mult
XMPRED_r_1_2  i_pred_1  vw_route_1_2  vss  vss  sky130_fd_pr__nfet_01v8  w=4  l=0.35
Cw_route_1_2  vw_route_1_2  vss  200f
R_bleed_1_2  vw_route_1_2  vss  10000meg
XMN4_r_1_2  vw_route_1_2  we_route  iwrite_route_1_2  vss  sky130_fd_pr__nfet_01v8  w=0.5  l=0.5
X_rhebb_1_2  iwrite_route_1_2  inp_upper_2  ierr_dig_1  vcm_route  vdd vss  hebbian_mult
XMPRED_r_1_3  i_pred_1  vw_route_1_3  vss  vss  sky130_fd_pr__nfet_01v8  w=4  l=0.35
Cw_route_1_3  vw_route_1_3  vss  200f
R_bleed_1_3  vw_route_1_3  vss  10000meg
XMN4_r_1_3  vw_route_1_3  we_route  iwrite_route_1_3  vss  sky130_fd_pr__nfet_01v8  w=0.5  l=0.5
X_rhebb_1_3  iwrite_route_1_3  inp_upper_3  ierr_dig_1  vcm_route  vdd vss  hebbian_mult
XMPRED_r_1_4  i_pred_1  vw_route_1_4  vss  vss  sky130_fd_pr__nfet_01v8  w=4  l=0.35
Cw_route_1_4  vw_route_1_4  vss  200f
R_bleed_1_4  vw_route_1_4  vss  10000meg
XMN4_r_1_4  vw_route_1_4  we_route  iwrite_route_1_4  vss  sky130_fd_pr__nfet_01v8  w=0.5  l=0.5
X_rhebb_1_4  iwrite_route_1_4  inp_upper_4  ierr_dig_1  vcm_route  vdd vss  hebbian_mult
XMPRED_r_1_5  i_pred_1  vw_route_1_5  vss  vss  sky130_fd_pr__nfet_01v8  w=4  l=0.35
Cw_route_1_5  vw_route_1_5  vss  200f
R_bleed_1_5  vw_route_1_5  vss  10000meg
XMN4_r_1_5  vw_route_1_5  we_route  iwrite_route_1_5  vss  sky130_fd_pr__nfet_01v8  w=0.5  l=0.5
X_rhebb_1_5  iwrite_route_1_5  inp_upper_5  ierr_dig_1  vcm_route  vdd vss  hebbian_mult
XMPRED_r_1_6  i_pred_1  vw_route_1_6  vss  vss  sky130_fd_pr__nfet_01v8  w=4  l=0.35
Cw_route_1_6  vw_route_1_6  vss  200f
R_bleed_1_6  vw_route_1_6  vss  10000meg
XMN4_r_1_6  vw_route_1_6  we_route  iwrite_route_1_6  vss  sky130_fd_pr__nfet_01v8  w=0.5  l=0.5
X_rhebb_1_6  iwrite_route_1_6  inp_upper_6  ierr_dig_1  vcm_route  vdd vss  hebbian_mult
XMPRED_r_1_7  i_pred_1  vw_route_1_7  vss  vss  sky130_fd_pr__nfet_01v8  w=4  l=0.35
Cw_route_1_7  vw_route_1_7  vss  200f
R_bleed_1_7  vw_route_1_7  vss  10000meg
XMN4_r_1_7  vw_route_1_7  we_route  iwrite_route_1_7  vss  sky130_fd_pr__nfet_01v8  w=0.5  l=0.5
X_rhebb_1_7  iwrite_route_1_7  inp_upper_7  ierr_dig_1  vcm_route  vdd vss  hebbian_mult
XMPRED_r_1_8  i_pred_1  vw_route_1_8  vss  vss  sky130_fd_pr__nfet_01v8  w=4  l=0.35
Cw_route_1_8  vw_route_1_8  vss  200f
R_bleed_1_8  vw_route_1_8  vss  10000meg
XMN4_r_1_8  vw_route_1_8  we_route  iwrite_route_1_8  vss  sky130_fd_pr__nfet_01v8  w=0.5  l=0.5
X_rhebb_1_8  iwrite_route_1_8  inp_upper_8  ierr_dig_1  vcm_route  vdd vss  hebbian_mult
XMPRED_r_1_9  i_pred_1  vw_route_1_9  vss  vss  sky130_fd_pr__nfet_01v8  w=4  l=0.35
Cw_route_1_9  vw_route_1_9  vss  200f
R_bleed_1_9  vw_route_1_9  vss  10000meg
XMN4_r_1_9  vw_route_1_9  we_route  iwrite_route_1_9  vss  sky130_fd_pr__nfet_01v8  w=0.5  l=0.5
X_rhebb_1_9  iwrite_route_1_9  inp_upper_9  ierr_dig_1  vcm_route  vdd vss  hebbian_mult
XMPRED_r_1_10  i_pred_1  vw_route_1_10  vss  vss  sky130_fd_pr__nfet_01v8  w=4  l=0.35
Cw_route_1_10  vw_route_1_10  vss  200f
R_bleed_1_10  vw_route_1_10  vss  10000meg
XMN4_r_1_10  vw_route_1_10  we_route  iwrite_route_1_10  vss  sky130_fd_pr__nfet_01v8  w=0.5  l=0.5
X_rhebb_1_10  iwrite_route_1_10  inp_upper_10  ierr_dig_1  vcm_route  vdd vss  hebbian_mult
XMPRED_r_1_11  i_pred_1  vw_route_1_11  vss  vss  sky130_fd_pr__nfet_01v8  w=4  l=0.35
Cw_route_1_11  vw_route_1_11  vss  200f
R_bleed_1_11  vw_route_1_11  vss  10000meg
XMN4_r_1_11  vw_route_1_11  we_route  iwrite_route_1_11  vss  sky130_fd_pr__nfet_01v8  w=0.5  l=0.5
X_rhebb_1_11  iwrite_route_1_11  inp_upper_11  ierr_dig_1  vcm_route  vdd vss  hebbian_mult
XMPRED_r_1_12  i_pred_1  vw_route_1_12  vss  vss  sky130_fd_pr__nfet_01v8  w=4  l=0.35
Cw_route_1_12  vw_route_1_12  vss  200f
R_bleed_1_12  vw_route_1_12  vss  10000meg
XMN4_r_1_12  vw_route_1_12  we_route  iwrite_route_1_12  vss  sky130_fd_pr__nfet_01v8  w=0.5  l=0.5
X_rhebb_1_12  iwrite_route_1_12  inp_upper_12  ierr_dig_1  vcm_route  vdd vss  hebbian_mult
XMPRED_r_1_13  i_pred_1  vw_route_1_13  vss  vss  sky130_fd_pr__nfet_01v8  w=4  l=0.35
Cw_route_1_13  vw_route_1_13  vss  200f
R_bleed_1_13  vw_route_1_13  vss  10000meg
XMN4_r_1_13  vw_route_1_13  we_route  iwrite_route_1_13  vss  sky130_fd_pr__nfet_01v8  w=0.5  l=0.5
X_rhebb_1_13  iwrite_route_1_13  inp_upper_13  ierr_dig_1  vcm_route  vdd vss  hebbian_mult
XMPRED_r_1_14  i_pred_1  vw_route_1_14  vss  vss  sky130_fd_pr__nfet_01v8  w=4  l=0.35
Cw_route_1_14  vw_route_1_14  vss  200f
R_bleed_1_14  vw_route_1_14  vss  10000meg
XMN4_r_1_14  vw_route_1_14  we_route  iwrite_route_1_14  vss  sky130_fd_pr__nfet_01v8  w=0.5  l=0.5
X_rhebb_1_14  iwrite_route_1_14  inp_upper_14  ierr_dig_1  vcm_route  vdd vss  hebbian_mult
XMPRED_r_1_15  i_pred_1  vw_route_1_15  vss  vss  sky130_fd_pr__nfet_01v8  w=4  l=0.35
Cw_route_1_15  vw_route_1_15  vss  200f
R_bleed_1_15  vw_route_1_15  vss  10000meg
XMN4_r_1_15  vw_route_1_15  we_route  iwrite_route_1_15  vss  sky130_fd_pr__nfet_01v8  w=0.5  l=0.5
X_rhebb_1_15  iwrite_route_1_15  inp_upper_15  ierr_dig_1  vcm_route  vdd vss  hebbian_mult
XMPRED_r_1_16  i_pred_1  vw_route_1_16  vss  vss  sky130_fd_pr__nfet_01v8  w=4  l=0.35
Cw_route_1_16  vw_route_1_16  vss  200f
R_bleed_1_16  vw_route_1_16  vss  10000meg
XMN4_r_1_16  vw_route_1_16  we_route  iwrite_route_1_16  vss  sky130_fd_pr__nfet_01v8  w=0.5  l=0.5
X_rhebb_1_16  iwrite_route_1_16  inp_upper_16  ierr_dig_1  vcm_route  vdd vss  hebbian_mult
XMPRED_r_1_17  i_pred_1  vw_route_1_17  vss  vss  sky130_fd_pr__nfet_01v8  w=4  l=0.35
Cw_route_1_17  vw_route_1_17  vss  200f
R_bleed_1_17  vw_route_1_17  vss  10000meg
XMN4_r_1_17  vw_route_1_17  we_route  iwrite_route_1_17  vss  sky130_fd_pr__nfet_01v8  w=0.5  l=0.5
X_rhebb_1_17  iwrite_route_1_17  inp_upper_17  ierr_dig_1  vcm_route  vdd vss  hebbian_mult
XMPRED_r_1_18  i_pred_1  vw_route_1_18  vss  vss  sky130_fd_pr__nfet_01v8  w=4  l=0.35
Cw_route_1_18  vw_route_1_18  vss  200f
R_bleed_1_18  vw_route_1_18  vss  10000meg
XMN4_r_1_18  vw_route_1_18  we_route  iwrite_route_1_18  vss  sky130_fd_pr__nfet_01v8  w=0.5  l=0.5
X_rhebb_1_18  iwrite_route_1_18  inp_upper_18  ierr_dig_1  vcm_route  vdd vss  hebbian_mult
XMPRED_r_1_19  i_pred_1  vw_route_1_19  vss  vss  sky130_fd_pr__nfet_01v8  w=4  l=0.35
Cw_route_1_19  vw_route_1_19  vss  200f
R_bleed_1_19  vw_route_1_19  vss  10000meg
XMN4_r_1_19  vw_route_1_19  we_route  iwrite_route_1_19  vss  sky130_fd_pr__nfet_01v8  w=0.5  l=0.5
X_rhebb_1_19  iwrite_route_1_19  inp_upper_19  ierr_dig_1  vcm_route  vdd vss  hebbian_mult
XMPRED_r_1_20  i_pred_1  vw_route_1_20  vss  vss  sky130_fd_pr__nfet_01v8  w=4  l=0.35
Cw_route_1_20  vw_route_1_20  vss  200f
R_bleed_1_20  vw_route_1_20  vss  10000meg
XMN4_r_1_20  vw_route_1_20  we_route  iwrite_route_1_20  vss  sky130_fd_pr__nfet_01v8  w=0.5  l=0.5
X_rhebb_1_20  iwrite_route_1_20  inp_upper_20  ierr_dig_1  vcm_route  vdd vss  hebbian_mult
XMPRED_r_1_21  i_pred_1  vw_route_1_21  vss  vss  sky130_fd_pr__nfet_01v8  w=4  l=0.35
Cw_route_1_21  vw_route_1_21  vss  200f
R_bleed_1_21  vw_route_1_21  vss  10000meg
XMN4_r_1_21  vw_route_1_21  we_route  iwrite_route_1_21  vss  sky130_fd_pr__nfet_01v8  w=0.5  l=0.5
X_rhebb_1_21  iwrite_route_1_21  inp_upper_21  ierr_dig_1  vcm_route  vdd vss  hebbian_mult
XMPRED_r_1_22  i_pred_1  vw_route_1_22  vss  vss  sky130_fd_pr__nfet_01v8  w=4  l=0.35
Cw_route_1_22  vw_route_1_22  vss  200f
R_bleed_1_22  vw_route_1_22  vss  10000meg
XMN4_r_1_22  vw_route_1_22  we_route  iwrite_route_1_22  vss  sky130_fd_pr__nfet_01v8  w=0.5  l=0.5
X_rhebb_1_22  iwrite_route_1_22  inp_upper_22  ierr_dig_1  vcm_route  vdd vss  hebbian_mult
XMPRED_r_1_23  i_pred_1  vw_route_1_23  vss  vss  sky130_fd_pr__nfet_01v8  w=4  l=0.35
Cw_route_1_23  vw_route_1_23  vss  200f
R_bleed_1_23  vw_route_1_23  vss  10000meg
XMN4_r_1_23  vw_route_1_23  we_route  iwrite_route_1_23  vss  sky130_fd_pr__nfet_01v8  w=0.5  l=0.5
X_rhebb_1_23  iwrite_route_1_23  inp_upper_23  ierr_dig_1  vcm_route  vdd vss  hebbian_mult
XMPRED_r_1_24  i_pred_1  vw_route_1_24  vss  vss  sky130_fd_pr__nfet_01v8  w=4  l=0.35
Cw_route_1_24  vw_route_1_24  vss  200f
R_bleed_1_24  vw_route_1_24  vss  10000meg
XMN4_r_1_24  vw_route_1_24  we_route  iwrite_route_1_24  vss  sky130_fd_pr__nfet_01v8  w=0.5  l=0.5
X_rhebb_1_24  iwrite_route_1_24  inp_upper_24  ierr_dig_1  vcm_route  vdd vss  hebbian_mult
XMPRED_r_1_25  i_pred_1  vw_route_1_25  vss  vss  sky130_fd_pr__nfet_01v8  w=4  l=0.35
Cw_route_1_25  vw_route_1_25  vss  200f
R_bleed_1_25  vw_route_1_25  vss  10000meg
XMN4_r_1_25  vw_route_1_25  we_route  iwrite_route_1_25  vss  sky130_fd_pr__nfet_01v8  w=0.5  l=0.5
X_rhebb_1_25  iwrite_route_1_25  inp_upper_25  ierr_dig_1  vcm_route  vdd vss  hebbian_mult
XMPRED_r_1_26  i_pred_1  vw_route_1_26  vss  vss  sky130_fd_pr__nfet_01v8  w=4  l=0.35
Cw_route_1_26  vw_route_1_26  vss  200f
R_bleed_1_26  vw_route_1_26  vss  10000meg
XMN4_r_1_26  vw_route_1_26  we_route  iwrite_route_1_26  vss  sky130_fd_pr__nfet_01v8  w=0.5  l=0.5
X_rhebb_1_26  iwrite_route_1_26  inp_upper_26  ierr_dig_1  vcm_route  vdd vss  hebbian_mult
XMPRED_r_1_27  i_pred_1  vw_route_1_27  vss  vss  sky130_fd_pr__nfet_01v8  w=4  l=0.35
Cw_route_1_27  vw_route_1_27  vss  200f
R_bleed_1_27  vw_route_1_27  vss  10000meg
XMN4_r_1_27  vw_route_1_27  we_route  iwrite_route_1_27  vss  sky130_fd_pr__nfet_01v8  w=0.5  l=0.5
X_rhebb_1_27  iwrite_route_1_27  inp_upper_27  ierr_dig_1  vcm_route  vdd vss  hebbian_mult
XMPRED_r_1_28  i_pred_1  vw_route_1_28  vss  vss  sky130_fd_pr__nfet_01v8  w=4  l=0.35
Cw_route_1_28  vw_route_1_28  vss  200f
R_bleed_1_28  vw_route_1_28  vss  10000meg
XMN4_r_1_28  vw_route_1_28  we_route  iwrite_route_1_28  vss  sky130_fd_pr__nfet_01v8  w=0.5  l=0.5
X_rhebb_1_28  iwrite_route_1_28  inp_upper_28  ierr_dig_1  vcm_route  vdd vss  hebbian_mult
XMPRED_r_1_29  i_pred_1  vw_route_1_29  vss  vss  sky130_fd_pr__nfet_01v8  w=4  l=0.35
Cw_route_1_29  vw_route_1_29  vss  200f
R_bleed_1_29  vw_route_1_29  vss  10000meg
XMN4_r_1_29  vw_route_1_29  we_route  iwrite_route_1_29  vss  sky130_fd_pr__nfet_01v8  w=0.5  l=0.5
X_rhebb_1_29  iwrite_route_1_29  inp_upper_29  ierr_dig_1  vcm_route  vdd vss  hebbian_mult
XMPRED_r_1_30  i_pred_1  vw_route_1_30  vss  vss  sky130_fd_pr__nfet_01v8  w=4  l=0.35
Cw_route_1_30  vw_route_1_30  vss  200f
R_bleed_1_30  vw_route_1_30  vss  10000meg
XMN4_r_1_30  vw_route_1_30  we_route  iwrite_route_1_30  vss  sky130_fd_pr__nfet_01v8  w=0.5  l=0.5
X_rhebb_1_30  iwrite_route_1_30  inp_upper_30  ierr_dig_1  vcm_route  vdd vss  hebbian_mult
XMPRED_r_1_31  i_pred_1  vw_route_1_31  vss  vss  sky130_fd_pr__nfet_01v8  w=4  l=0.35
Cw_route_1_31  vw_route_1_31  vss  200f
R_bleed_1_31  vw_route_1_31  vss  10000meg
XMN4_r_1_31  vw_route_1_31  we_route  iwrite_route_1_31  vss  sky130_fd_pr__nfet_01v8  w=0.5  l=0.5
X_rhebb_1_31  iwrite_route_1_31  inp_upper_31  ierr_dig_1  vcm_route  vdd vss  hebbian_mult

* ── Destination row 2 ── 32 source connections ──────────────────────────
XMPRED_r_2_0  i_pred_2  vw_route_2_0  vss  vss  sky130_fd_pr__nfet_01v8  w=4  l=0.35
Cw_route_2_0  vw_route_2_0  vss  200f
R_bleed_2_0  vw_route_2_0  vss  10000meg
XMN4_r_2_0  vw_route_2_0  we_route  iwrite_route_2_0  vss  sky130_fd_pr__nfet_01v8  w=0.5  l=0.5
X_rhebb_2_0  iwrite_route_2_0  inp_upper_0  ierr_dig_2  vcm_route  vdd vss  hebbian_mult
XMPRED_r_2_1  i_pred_2  vw_route_2_1  vss  vss  sky130_fd_pr__nfet_01v8  w=4  l=0.35
Cw_route_2_1  vw_route_2_1  vss  200f
R_bleed_2_1  vw_route_2_1  vss  10000meg
XMN4_r_2_1  vw_route_2_1  we_route  iwrite_route_2_1  vss  sky130_fd_pr__nfet_01v8  w=0.5  l=0.5
X_rhebb_2_1  iwrite_route_2_1  inp_upper_1  ierr_dig_2  vcm_route  vdd vss  hebbian_mult
XMPRED_r_2_2  i_pred_2  vw_route_2_2  vss  vss  sky130_fd_pr__nfet_01v8  w=4  l=0.35
Cw_route_2_2  vw_route_2_2  vss  200f
R_bleed_2_2  vw_route_2_2  vss  10000meg
XMN4_r_2_2  vw_route_2_2  we_route  iwrite_route_2_2  vss  sky130_fd_pr__nfet_01v8  w=0.5  l=0.5
X_rhebb_2_2  iwrite_route_2_2  inp_upper_2  ierr_dig_2  vcm_route  vdd vss  hebbian_mult
XMPRED_r_2_3  i_pred_2  vw_route_2_3  vss  vss  sky130_fd_pr__nfet_01v8  w=4  l=0.35
Cw_route_2_3  vw_route_2_3  vss  200f
R_bleed_2_3  vw_route_2_3  vss  10000meg
XMN4_r_2_3  vw_route_2_3  we_route  iwrite_route_2_3  vss  sky130_fd_pr__nfet_01v8  w=0.5  l=0.5
X_rhebb_2_3  iwrite_route_2_3  inp_upper_3  ierr_dig_2  vcm_route  vdd vss  hebbian_mult
XMPRED_r_2_4  i_pred_2  vw_route_2_4  vss  vss  sky130_fd_pr__nfet_01v8  w=4  l=0.35
Cw_route_2_4  vw_route_2_4  vss  200f
R_bleed_2_4  vw_route_2_4  vss  10000meg
XMN4_r_2_4  vw_route_2_4  we_route  iwrite_route_2_4  vss  sky130_fd_pr__nfet_01v8  w=0.5  l=0.5
X_rhebb_2_4  iwrite_route_2_4  inp_upper_4  ierr_dig_2  vcm_route  vdd vss  hebbian_mult
XMPRED_r_2_5  i_pred_2  vw_route_2_5  vss  vss  sky130_fd_pr__nfet_01v8  w=4  l=0.35
Cw_route_2_5  vw_route_2_5  vss  200f
R_bleed_2_5  vw_route_2_5  vss  10000meg
XMN4_r_2_5  vw_route_2_5  we_route  iwrite_route_2_5  vss  sky130_fd_pr__nfet_01v8  w=0.5  l=0.5
X_rhebb_2_5  iwrite_route_2_5  inp_upper_5  ierr_dig_2  vcm_route  vdd vss  hebbian_mult
XMPRED_r_2_6  i_pred_2  vw_route_2_6  vss  vss  sky130_fd_pr__nfet_01v8  w=4  l=0.35
Cw_route_2_6  vw_route_2_6  vss  200f
R_bleed_2_6  vw_route_2_6  vss  10000meg
XMN4_r_2_6  vw_route_2_6  we_route  iwrite_route_2_6  vss  sky130_fd_pr__nfet_01v8  w=0.5  l=0.5
X_rhebb_2_6  iwrite_route_2_6  inp_upper_6  ierr_dig_2  vcm_route  vdd vss  hebbian_mult
XMPRED_r_2_7  i_pred_2  vw_route_2_7  vss  vss  sky130_fd_pr__nfet_01v8  w=4  l=0.35
Cw_route_2_7  vw_route_2_7  vss  200f
R_bleed_2_7  vw_route_2_7  vss  10000meg
XMN4_r_2_7  vw_route_2_7  we_route  iwrite_route_2_7  vss  sky130_fd_pr__nfet_01v8  w=0.5  l=0.5
X_rhebb_2_7  iwrite_route_2_7  inp_upper_7  ierr_dig_2  vcm_route  vdd vss  hebbian_mult
XMPRED_r_2_8  i_pred_2  vw_route_2_8  vss  vss  sky130_fd_pr__nfet_01v8  w=4  l=0.35
Cw_route_2_8  vw_route_2_8  vss  200f
R_bleed_2_8  vw_route_2_8  vss  10000meg
XMN4_r_2_8  vw_route_2_8  we_route  iwrite_route_2_8  vss  sky130_fd_pr__nfet_01v8  w=0.5  l=0.5
X_rhebb_2_8  iwrite_route_2_8  inp_upper_8  ierr_dig_2  vcm_route  vdd vss  hebbian_mult
XMPRED_r_2_9  i_pred_2  vw_route_2_9  vss  vss  sky130_fd_pr__nfet_01v8  w=4  l=0.35
Cw_route_2_9  vw_route_2_9  vss  200f
R_bleed_2_9  vw_route_2_9  vss  10000meg
XMN4_r_2_9  vw_route_2_9  we_route  iwrite_route_2_9  vss  sky130_fd_pr__nfet_01v8  w=0.5  l=0.5
X_rhebb_2_9  iwrite_route_2_9  inp_upper_9  ierr_dig_2  vcm_route  vdd vss  hebbian_mult
XMPRED_r_2_10  i_pred_2  vw_route_2_10  vss  vss  sky130_fd_pr__nfet_01v8  w=4  l=0.35
Cw_route_2_10  vw_route_2_10  vss  200f
R_bleed_2_10  vw_route_2_10  vss  10000meg
XMN4_r_2_10  vw_route_2_10  we_route  iwrite_route_2_10  vss  sky130_fd_pr__nfet_01v8  w=0.5  l=0.5
X_rhebb_2_10  iwrite_route_2_10  inp_upper_10  ierr_dig_2  vcm_route  vdd vss  hebbian_mult
XMPRED_r_2_11  i_pred_2  vw_route_2_11  vss  vss  sky130_fd_pr__nfet_01v8  w=4  l=0.35
Cw_route_2_11  vw_route_2_11  vss  200f
R_bleed_2_11  vw_route_2_11  vss  10000meg
XMN4_r_2_11  vw_route_2_11  we_route  iwrite_route_2_11  vss  sky130_fd_pr__nfet_01v8  w=0.5  l=0.5
X_rhebb_2_11  iwrite_route_2_11  inp_upper_11  ierr_dig_2  vcm_route  vdd vss  hebbian_mult
XMPRED_r_2_12  i_pred_2  vw_route_2_12  vss  vss  sky130_fd_pr__nfet_01v8  w=4  l=0.35
Cw_route_2_12  vw_route_2_12  vss  200f
R_bleed_2_12  vw_route_2_12  vss  10000meg
XMN4_r_2_12  vw_route_2_12  we_route  iwrite_route_2_12  vss  sky130_fd_pr__nfet_01v8  w=0.5  l=0.5
X_rhebb_2_12  iwrite_route_2_12  inp_upper_12  ierr_dig_2  vcm_route  vdd vss  hebbian_mult
XMPRED_r_2_13  i_pred_2  vw_route_2_13  vss  vss  sky130_fd_pr__nfet_01v8  w=4  l=0.35
Cw_route_2_13  vw_route_2_13  vss  200f
R_bleed_2_13  vw_route_2_13  vss  10000meg
XMN4_r_2_13  vw_route_2_13  we_route  iwrite_route_2_13  vss  sky130_fd_pr__nfet_01v8  w=0.5  l=0.5
X_rhebb_2_13  iwrite_route_2_13  inp_upper_13  ierr_dig_2  vcm_route  vdd vss  hebbian_mult
XMPRED_r_2_14  i_pred_2  vw_route_2_14  vss  vss  sky130_fd_pr__nfet_01v8  w=4  l=0.35
Cw_route_2_14  vw_route_2_14  vss  200f
R_bleed_2_14  vw_route_2_14  vss  10000meg
XMN4_r_2_14  vw_route_2_14  we_route  iwrite_route_2_14  vss  sky130_fd_pr__nfet_01v8  w=0.5  l=0.5
X_rhebb_2_14  iwrite_route_2_14  inp_upper_14  ierr_dig_2  vcm_route  vdd vss  hebbian_mult
XMPRED_r_2_15  i_pred_2  vw_route_2_15  vss  vss  sky130_fd_pr__nfet_01v8  w=4  l=0.35
Cw_route_2_15  vw_route_2_15  vss  200f
R_bleed_2_15  vw_route_2_15  vss  10000meg
XMN4_r_2_15  vw_route_2_15  we_route  iwrite_route_2_15  vss  sky130_fd_pr__nfet_01v8  w=0.5  l=0.5
X_rhebb_2_15  iwrite_route_2_15  inp_upper_15  ierr_dig_2  vcm_route  vdd vss  hebbian_mult
XMPRED_r_2_16  i_pred_2  vw_route_2_16  vss  vss  sky130_fd_pr__nfet_01v8  w=4  l=0.35
Cw_route_2_16  vw_route_2_16  vss  200f
R_bleed_2_16  vw_route_2_16  vss  10000meg
XMN4_r_2_16  vw_route_2_16  we_route  iwrite_route_2_16  vss  sky130_fd_pr__nfet_01v8  w=0.5  l=0.5
X_rhebb_2_16  iwrite_route_2_16  inp_upper_16  ierr_dig_2  vcm_route  vdd vss  hebbian_mult
XMPRED_r_2_17  i_pred_2  vw_route_2_17  vss  vss  sky130_fd_pr__nfet_01v8  w=4  l=0.35
Cw_route_2_17  vw_route_2_17  vss  200f
R_bleed_2_17  vw_route_2_17  vss  10000meg
XMN4_r_2_17  vw_route_2_17  we_route  iwrite_route_2_17  vss  sky130_fd_pr__nfet_01v8  w=0.5  l=0.5
X_rhebb_2_17  iwrite_route_2_17  inp_upper_17  ierr_dig_2  vcm_route  vdd vss  hebbian_mult
XMPRED_r_2_18  i_pred_2  vw_route_2_18  vss  vss  sky130_fd_pr__nfet_01v8  w=4  l=0.35
Cw_route_2_18  vw_route_2_18  vss  200f
R_bleed_2_18  vw_route_2_18  vss  10000meg
XMN4_r_2_18  vw_route_2_18  we_route  iwrite_route_2_18  vss  sky130_fd_pr__nfet_01v8  w=0.5  l=0.5
X_rhebb_2_18  iwrite_route_2_18  inp_upper_18  ierr_dig_2  vcm_route  vdd vss  hebbian_mult
XMPRED_r_2_19  i_pred_2  vw_route_2_19  vss  vss  sky130_fd_pr__nfet_01v8  w=4  l=0.35
Cw_route_2_19  vw_route_2_19  vss  200f
R_bleed_2_19  vw_route_2_19  vss  10000meg
XMN4_r_2_19  vw_route_2_19  we_route  iwrite_route_2_19  vss  sky130_fd_pr__nfet_01v8  w=0.5  l=0.5
X_rhebb_2_19  iwrite_route_2_19  inp_upper_19  ierr_dig_2  vcm_route  vdd vss  hebbian_mult
XMPRED_r_2_20  i_pred_2  vw_route_2_20  vss  vss  sky130_fd_pr__nfet_01v8  w=4  l=0.35
Cw_route_2_20  vw_route_2_20  vss  200f
R_bleed_2_20  vw_route_2_20  vss  10000meg
XMN4_r_2_20  vw_route_2_20  we_route  iwrite_route_2_20  vss  sky130_fd_pr__nfet_01v8  w=0.5  l=0.5
X_rhebb_2_20  iwrite_route_2_20  inp_upper_20  ierr_dig_2  vcm_route  vdd vss  hebbian_mult
XMPRED_r_2_21  i_pred_2  vw_route_2_21  vss  vss  sky130_fd_pr__nfet_01v8  w=4  l=0.35
Cw_route_2_21  vw_route_2_21  vss  200f
R_bleed_2_21  vw_route_2_21  vss  10000meg
XMN4_r_2_21  vw_route_2_21  we_route  iwrite_route_2_21  vss  sky130_fd_pr__nfet_01v8  w=0.5  l=0.5
X_rhebb_2_21  iwrite_route_2_21  inp_upper_21  ierr_dig_2  vcm_route  vdd vss  hebbian_mult
XMPRED_r_2_22  i_pred_2  vw_route_2_22  vss  vss  sky130_fd_pr__nfet_01v8  w=4  l=0.35
Cw_route_2_22  vw_route_2_22  vss  200f
R_bleed_2_22  vw_route_2_22  vss  10000meg
XMN4_r_2_22  vw_route_2_22  we_route  iwrite_route_2_22  vss  sky130_fd_pr__nfet_01v8  w=0.5  l=0.5
X_rhebb_2_22  iwrite_route_2_22  inp_upper_22  ierr_dig_2  vcm_route  vdd vss  hebbian_mult
XMPRED_r_2_23  i_pred_2  vw_route_2_23  vss  vss  sky130_fd_pr__nfet_01v8  w=4  l=0.35
Cw_route_2_23  vw_route_2_23  vss  200f
R_bleed_2_23  vw_route_2_23  vss  10000meg
XMN4_r_2_23  vw_route_2_23  we_route  iwrite_route_2_23  vss  sky130_fd_pr__nfet_01v8  w=0.5  l=0.5
X_rhebb_2_23  iwrite_route_2_23  inp_upper_23  ierr_dig_2  vcm_route  vdd vss  hebbian_mult
XMPRED_r_2_24  i_pred_2  vw_route_2_24  vss  vss  sky130_fd_pr__nfet_01v8  w=4  l=0.35
Cw_route_2_24  vw_route_2_24  vss  200f
R_bleed_2_24  vw_route_2_24  vss  10000meg
XMN4_r_2_24  vw_route_2_24  we_route  iwrite_route_2_24  vss  sky130_fd_pr__nfet_01v8  w=0.5  l=0.5
X_rhebb_2_24  iwrite_route_2_24  inp_upper_24  ierr_dig_2  vcm_route  vdd vss  hebbian_mult
XMPRED_r_2_25  i_pred_2  vw_route_2_25  vss  vss  sky130_fd_pr__nfet_01v8  w=4  l=0.35
Cw_route_2_25  vw_route_2_25  vss  200f
R_bleed_2_25  vw_route_2_25  vss  10000meg
XMN4_r_2_25  vw_route_2_25  we_route  iwrite_route_2_25  vss  sky130_fd_pr__nfet_01v8  w=0.5  l=0.5
X_rhebb_2_25  iwrite_route_2_25  inp_upper_25  ierr_dig_2  vcm_route  vdd vss  hebbian_mult
XMPRED_r_2_26  i_pred_2  vw_route_2_26  vss  vss  sky130_fd_pr__nfet_01v8  w=4  l=0.35
Cw_route_2_26  vw_route_2_26  vss  200f
R_bleed_2_26  vw_route_2_26  vss  10000meg
XMN4_r_2_26  vw_route_2_26  we_route  iwrite_route_2_26  vss  sky130_fd_pr__nfet_01v8  w=0.5  l=0.5
X_rhebb_2_26  iwrite_route_2_26  inp_upper_26  ierr_dig_2  vcm_route  vdd vss  hebbian_mult
XMPRED_r_2_27  i_pred_2  vw_route_2_27  vss  vss  sky130_fd_pr__nfet_01v8  w=4  l=0.35
Cw_route_2_27  vw_route_2_27  vss  200f
R_bleed_2_27  vw_route_2_27  vss  10000meg
XMN4_r_2_27  vw_route_2_27  we_route  iwrite_route_2_27  vss  sky130_fd_pr__nfet_01v8  w=0.5  l=0.5
X_rhebb_2_27  iwrite_route_2_27  inp_upper_27  ierr_dig_2  vcm_route  vdd vss  hebbian_mult
XMPRED_r_2_28  i_pred_2  vw_route_2_28  vss  vss  sky130_fd_pr__nfet_01v8  w=4  l=0.35
Cw_route_2_28  vw_route_2_28  vss  200f
R_bleed_2_28  vw_route_2_28  vss  10000meg
XMN4_r_2_28  vw_route_2_28  we_route  iwrite_route_2_28  vss  sky130_fd_pr__nfet_01v8  w=0.5  l=0.5
X_rhebb_2_28  iwrite_route_2_28  inp_upper_28  ierr_dig_2  vcm_route  vdd vss  hebbian_mult
XMPRED_r_2_29  i_pred_2  vw_route_2_29  vss  vss  sky130_fd_pr__nfet_01v8  w=4  l=0.35
Cw_route_2_29  vw_route_2_29  vss  200f
R_bleed_2_29  vw_route_2_29  vss  10000meg
XMN4_r_2_29  vw_route_2_29  we_route  iwrite_route_2_29  vss  sky130_fd_pr__nfet_01v8  w=0.5  l=0.5
X_rhebb_2_29  iwrite_route_2_29  inp_upper_29  ierr_dig_2  vcm_route  vdd vss  hebbian_mult
XMPRED_r_2_30  i_pred_2  vw_route_2_30  vss  vss  sky130_fd_pr__nfet_01v8  w=4  l=0.35
Cw_route_2_30  vw_route_2_30  vss  200f
R_bleed_2_30  vw_route_2_30  vss  10000meg
XMN4_r_2_30  vw_route_2_30  we_route  iwrite_route_2_30  vss  sky130_fd_pr__nfet_01v8  w=0.5  l=0.5
X_rhebb_2_30  iwrite_route_2_30  inp_upper_30  ierr_dig_2  vcm_route  vdd vss  hebbian_mult
XMPRED_r_2_31  i_pred_2  vw_route_2_31  vss  vss  sky130_fd_pr__nfet_01v8  w=4  l=0.35
Cw_route_2_31  vw_route_2_31  vss  200f
R_bleed_2_31  vw_route_2_31  vss  10000meg
XMN4_r_2_31  vw_route_2_31  we_route  iwrite_route_2_31  vss  sky130_fd_pr__nfet_01v8  w=0.5  l=0.5
X_rhebb_2_31  iwrite_route_2_31  inp_upper_31  ierr_dig_2  vcm_route  vdd vss  hebbian_mult

* ── Destination row 3 ── 32 source connections ──────────────────────────
XMPRED_r_3_0  i_pred_3  vw_route_3_0  vss  vss  sky130_fd_pr__nfet_01v8  w=4  l=0.35
Cw_route_3_0  vw_route_3_0  vss  200f
R_bleed_3_0  vw_route_3_0  vss  10000meg
XMN4_r_3_0  vw_route_3_0  we_route  iwrite_route_3_0  vss  sky130_fd_pr__nfet_01v8  w=0.5  l=0.5
X_rhebb_3_0  iwrite_route_3_0  inp_upper_0  ierr_dig_3  vcm_route  vdd vss  hebbian_mult
XMPRED_r_3_1  i_pred_3  vw_route_3_1  vss  vss  sky130_fd_pr__nfet_01v8  w=4  l=0.35
Cw_route_3_1  vw_route_3_1  vss  200f
R_bleed_3_1  vw_route_3_1  vss  10000meg
XMN4_r_3_1  vw_route_3_1  we_route  iwrite_route_3_1  vss  sky130_fd_pr__nfet_01v8  w=0.5  l=0.5
X_rhebb_3_1  iwrite_route_3_1  inp_upper_1  ierr_dig_3  vcm_route  vdd vss  hebbian_mult
XMPRED_r_3_2  i_pred_3  vw_route_3_2  vss  vss  sky130_fd_pr__nfet_01v8  w=4  l=0.35
Cw_route_3_2  vw_route_3_2  vss  200f
R_bleed_3_2  vw_route_3_2  vss  10000meg
XMN4_r_3_2  vw_route_3_2  we_route  iwrite_route_3_2  vss  sky130_fd_pr__nfet_01v8  w=0.5  l=0.5
X_rhebb_3_2  iwrite_route_3_2  inp_upper_2  ierr_dig_3  vcm_route  vdd vss  hebbian_mult
XMPRED_r_3_3  i_pred_3  vw_route_3_3  vss  vss  sky130_fd_pr__nfet_01v8  w=4  l=0.35
Cw_route_3_3  vw_route_3_3  vss  200f
R_bleed_3_3  vw_route_3_3  vss  10000meg
XMN4_r_3_3  vw_route_3_3  we_route  iwrite_route_3_3  vss  sky130_fd_pr__nfet_01v8  w=0.5  l=0.5
X_rhebb_3_3  iwrite_route_3_3  inp_upper_3  ierr_dig_3  vcm_route  vdd vss  hebbian_mult
XMPRED_r_3_4  i_pred_3  vw_route_3_4  vss  vss  sky130_fd_pr__nfet_01v8  w=4  l=0.35
Cw_route_3_4  vw_route_3_4  vss  200f
R_bleed_3_4  vw_route_3_4  vss  10000meg
XMN4_r_3_4  vw_route_3_4  we_route  iwrite_route_3_4  vss  sky130_fd_pr__nfet_01v8  w=0.5  l=0.5
X_rhebb_3_4  iwrite_route_3_4  inp_upper_4  ierr_dig_3  vcm_route  vdd vss  hebbian_mult
XMPRED_r_3_5  i_pred_3  vw_route_3_5  vss  vss  sky130_fd_pr__nfet_01v8  w=4  l=0.35
Cw_route_3_5  vw_route_3_5  vss  200f
R_bleed_3_5  vw_route_3_5  vss  10000meg
XMN4_r_3_5  vw_route_3_5  we_route  iwrite_route_3_5  vss  sky130_fd_pr__nfet_01v8  w=0.5  l=0.5
X_rhebb_3_5  iwrite_route_3_5  inp_upper_5  ierr_dig_3  vcm_route  vdd vss  hebbian_mult
XMPRED_r_3_6  i_pred_3  vw_route_3_6  vss  vss  sky130_fd_pr__nfet_01v8  w=4  l=0.35
Cw_route_3_6  vw_route_3_6  vss  200f
R_bleed_3_6  vw_route_3_6  vss  10000meg
XMN4_r_3_6  vw_route_3_6  we_route  iwrite_route_3_6  vss  sky130_fd_pr__nfet_01v8  w=0.5  l=0.5
X_rhebb_3_6  iwrite_route_3_6  inp_upper_6  ierr_dig_3  vcm_route  vdd vss  hebbian_mult
XMPRED_r_3_7  i_pred_3  vw_route_3_7  vss  vss  sky130_fd_pr__nfet_01v8  w=4  l=0.35
Cw_route_3_7  vw_route_3_7  vss  200f
R_bleed_3_7  vw_route_3_7  vss  10000meg
XMN4_r_3_7  vw_route_3_7  we_route  iwrite_route_3_7  vss  sky130_fd_pr__nfet_01v8  w=0.5  l=0.5
X_rhebb_3_7  iwrite_route_3_7  inp_upper_7  ierr_dig_3  vcm_route  vdd vss  hebbian_mult
XMPRED_r_3_8  i_pred_3  vw_route_3_8  vss  vss  sky130_fd_pr__nfet_01v8  w=4  l=0.35
Cw_route_3_8  vw_route_3_8  vss  200f
R_bleed_3_8  vw_route_3_8  vss  10000meg
XMN4_r_3_8  vw_route_3_8  we_route  iwrite_route_3_8  vss  sky130_fd_pr__nfet_01v8  w=0.5  l=0.5
X_rhebb_3_8  iwrite_route_3_8  inp_upper_8  ierr_dig_3  vcm_route  vdd vss  hebbian_mult
XMPRED_r_3_9  i_pred_3  vw_route_3_9  vss  vss  sky130_fd_pr__nfet_01v8  w=4  l=0.35
Cw_route_3_9  vw_route_3_9  vss  200f
R_bleed_3_9  vw_route_3_9  vss  10000meg
XMN4_r_3_9  vw_route_3_9  we_route  iwrite_route_3_9  vss  sky130_fd_pr__nfet_01v8  w=0.5  l=0.5
X_rhebb_3_9  iwrite_route_3_9  inp_upper_9  ierr_dig_3  vcm_route  vdd vss  hebbian_mult
XMPRED_r_3_10  i_pred_3  vw_route_3_10  vss  vss  sky130_fd_pr__nfet_01v8  w=4  l=0.35
Cw_route_3_10  vw_route_3_10  vss  200f
R_bleed_3_10  vw_route_3_10  vss  10000meg
XMN4_r_3_10  vw_route_3_10  we_route  iwrite_route_3_10  vss  sky130_fd_pr__nfet_01v8  w=0.5  l=0.5
X_rhebb_3_10  iwrite_route_3_10  inp_upper_10  ierr_dig_3  vcm_route  vdd vss  hebbian_mult
XMPRED_r_3_11  i_pred_3  vw_route_3_11  vss  vss  sky130_fd_pr__nfet_01v8  w=4  l=0.35
Cw_route_3_11  vw_route_3_11  vss  200f
R_bleed_3_11  vw_route_3_11  vss  10000meg
XMN4_r_3_11  vw_route_3_11  we_route  iwrite_route_3_11  vss  sky130_fd_pr__nfet_01v8  w=0.5  l=0.5
X_rhebb_3_11  iwrite_route_3_11  inp_upper_11  ierr_dig_3  vcm_route  vdd vss  hebbian_mult
XMPRED_r_3_12  i_pred_3  vw_route_3_12  vss  vss  sky130_fd_pr__nfet_01v8  w=4  l=0.35
Cw_route_3_12  vw_route_3_12  vss  200f
R_bleed_3_12  vw_route_3_12  vss  10000meg
XMN4_r_3_12  vw_route_3_12  we_route  iwrite_route_3_12  vss  sky130_fd_pr__nfet_01v8  w=0.5  l=0.5
X_rhebb_3_12  iwrite_route_3_12  inp_upper_12  ierr_dig_3  vcm_route  vdd vss  hebbian_mult
XMPRED_r_3_13  i_pred_3  vw_route_3_13  vss  vss  sky130_fd_pr__nfet_01v8  w=4  l=0.35
Cw_route_3_13  vw_route_3_13  vss  200f
R_bleed_3_13  vw_route_3_13  vss  10000meg
XMN4_r_3_13  vw_route_3_13  we_route  iwrite_route_3_13  vss  sky130_fd_pr__nfet_01v8  w=0.5  l=0.5
X_rhebb_3_13  iwrite_route_3_13  inp_upper_13  ierr_dig_3  vcm_route  vdd vss  hebbian_mult
XMPRED_r_3_14  i_pred_3  vw_route_3_14  vss  vss  sky130_fd_pr__nfet_01v8  w=4  l=0.35
Cw_route_3_14  vw_route_3_14  vss  200f
R_bleed_3_14  vw_route_3_14  vss  10000meg
XMN4_r_3_14  vw_route_3_14  we_route  iwrite_route_3_14  vss  sky130_fd_pr__nfet_01v8  w=0.5  l=0.5
X_rhebb_3_14  iwrite_route_3_14  inp_upper_14  ierr_dig_3  vcm_route  vdd vss  hebbian_mult
XMPRED_r_3_15  i_pred_3  vw_route_3_15  vss  vss  sky130_fd_pr__nfet_01v8  w=4  l=0.35
Cw_route_3_15  vw_route_3_15  vss  200f
R_bleed_3_15  vw_route_3_15  vss  10000meg
XMN4_r_3_15  vw_route_3_15  we_route  iwrite_route_3_15  vss  sky130_fd_pr__nfet_01v8  w=0.5  l=0.5
X_rhebb_3_15  iwrite_route_3_15  inp_upper_15  ierr_dig_3  vcm_route  vdd vss  hebbian_mult
XMPRED_r_3_16  i_pred_3  vw_route_3_16  vss  vss  sky130_fd_pr__nfet_01v8  w=4  l=0.35
Cw_route_3_16  vw_route_3_16  vss  200f
R_bleed_3_16  vw_route_3_16  vss  10000meg
XMN4_r_3_16  vw_route_3_16  we_route  iwrite_route_3_16  vss  sky130_fd_pr__nfet_01v8  w=0.5  l=0.5
X_rhebb_3_16  iwrite_route_3_16  inp_upper_16  ierr_dig_3  vcm_route  vdd vss  hebbian_mult
XMPRED_r_3_17  i_pred_3  vw_route_3_17  vss  vss  sky130_fd_pr__nfet_01v8  w=4  l=0.35
Cw_route_3_17  vw_route_3_17  vss  200f
R_bleed_3_17  vw_route_3_17  vss  10000meg
XMN4_r_3_17  vw_route_3_17  we_route  iwrite_route_3_17  vss  sky130_fd_pr__nfet_01v8  w=0.5  l=0.5
X_rhebb_3_17  iwrite_route_3_17  inp_upper_17  ierr_dig_3  vcm_route  vdd vss  hebbian_mult
XMPRED_r_3_18  i_pred_3  vw_route_3_18  vss  vss  sky130_fd_pr__nfet_01v8  w=4  l=0.35
Cw_route_3_18  vw_route_3_18  vss  200f
R_bleed_3_18  vw_route_3_18  vss  10000meg
XMN4_r_3_18  vw_route_3_18  we_route  iwrite_route_3_18  vss  sky130_fd_pr__nfet_01v8  w=0.5  l=0.5
X_rhebb_3_18  iwrite_route_3_18  inp_upper_18  ierr_dig_3  vcm_route  vdd vss  hebbian_mult
XMPRED_r_3_19  i_pred_3  vw_route_3_19  vss  vss  sky130_fd_pr__nfet_01v8  w=4  l=0.35
Cw_route_3_19  vw_route_3_19  vss  200f
R_bleed_3_19  vw_route_3_19  vss  10000meg
XMN4_r_3_19  vw_route_3_19  we_route  iwrite_route_3_19  vss  sky130_fd_pr__nfet_01v8  w=0.5  l=0.5
X_rhebb_3_19  iwrite_route_3_19  inp_upper_19  ierr_dig_3  vcm_route  vdd vss  hebbian_mult
XMPRED_r_3_20  i_pred_3  vw_route_3_20  vss  vss  sky130_fd_pr__nfet_01v8  w=4  l=0.35
Cw_route_3_20  vw_route_3_20  vss  200f
R_bleed_3_20  vw_route_3_20  vss  10000meg
XMN4_r_3_20  vw_route_3_20  we_route  iwrite_route_3_20  vss  sky130_fd_pr__nfet_01v8  w=0.5  l=0.5
X_rhebb_3_20  iwrite_route_3_20  inp_upper_20  ierr_dig_3  vcm_route  vdd vss  hebbian_mult
XMPRED_r_3_21  i_pred_3  vw_route_3_21  vss  vss  sky130_fd_pr__nfet_01v8  w=4  l=0.35
Cw_route_3_21  vw_route_3_21  vss  200f
R_bleed_3_21  vw_route_3_21  vss  10000meg
XMN4_r_3_21  vw_route_3_21  we_route  iwrite_route_3_21  vss  sky130_fd_pr__nfet_01v8  w=0.5  l=0.5
X_rhebb_3_21  iwrite_route_3_21  inp_upper_21  ierr_dig_3  vcm_route  vdd vss  hebbian_mult
XMPRED_r_3_22  i_pred_3  vw_route_3_22  vss  vss  sky130_fd_pr__nfet_01v8  w=4  l=0.35
Cw_route_3_22  vw_route_3_22  vss  200f
R_bleed_3_22  vw_route_3_22  vss  10000meg
XMN4_r_3_22  vw_route_3_22  we_route  iwrite_route_3_22  vss  sky130_fd_pr__nfet_01v8  w=0.5  l=0.5
X_rhebb_3_22  iwrite_route_3_22  inp_upper_22  ierr_dig_3  vcm_route  vdd vss  hebbian_mult
XMPRED_r_3_23  i_pred_3  vw_route_3_23  vss  vss  sky130_fd_pr__nfet_01v8  w=4  l=0.35
Cw_route_3_23  vw_route_3_23  vss  200f
R_bleed_3_23  vw_route_3_23  vss  10000meg
XMN4_r_3_23  vw_route_3_23  we_route  iwrite_route_3_23  vss  sky130_fd_pr__nfet_01v8  w=0.5  l=0.5
X_rhebb_3_23  iwrite_route_3_23  inp_upper_23  ierr_dig_3  vcm_route  vdd vss  hebbian_mult
XMPRED_r_3_24  i_pred_3  vw_route_3_24  vss  vss  sky130_fd_pr__nfet_01v8  w=4  l=0.35
Cw_route_3_24  vw_route_3_24  vss  200f
R_bleed_3_24  vw_route_3_24  vss  10000meg
XMN4_r_3_24  vw_route_3_24  we_route  iwrite_route_3_24  vss  sky130_fd_pr__nfet_01v8  w=0.5  l=0.5
X_rhebb_3_24  iwrite_route_3_24  inp_upper_24  ierr_dig_3  vcm_route  vdd vss  hebbian_mult
XMPRED_r_3_25  i_pred_3  vw_route_3_25  vss  vss  sky130_fd_pr__nfet_01v8  w=4  l=0.35
Cw_route_3_25  vw_route_3_25  vss  200f
R_bleed_3_25  vw_route_3_25  vss  10000meg
XMN4_r_3_25  vw_route_3_25  we_route  iwrite_route_3_25  vss  sky130_fd_pr__nfet_01v8  w=0.5  l=0.5
X_rhebb_3_25  iwrite_route_3_25  inp_upper_25  ierr_dig_3  vcm_route  vdd vss  hebbian_mult
XMPRED_r_3_26  i_pred_3  vw_route_3_26  vss  vss  sky130_fd_pr__nfet_01v8  w=4  l=0.35
Cw_route_3_26  vw_route_3_26  vss  200f
R_bleed_3_26  vw_route_3_26  vss  10000meg
XMN4_r_3_26  vw_route_3_26  we_route  iwrite_route_3_26  vss  sky130_fd_pr__nfet_01v8  w=0.5  l=0.5
X_rhebb_3_26  iwrite_route_3_26  inp_upper_26  ierr_dig_3  vcm_route  vdd vss  hebbian_mult
XMPRED_r_3_27  i_pred_3  vw_route_3_27  vss  vss  sky130_fd_pr__nfet_01v8  w=4  l=0.35
Cw_route_3_27  vw_route_3_27  vss  200f
R_bleed_3_27  vw_route_3_27  vss  10000meg
XMN4_r_3_27  vw_route_3_27  we_route  iwrite_route_3_27  vss  sky130_fd_pr__nfet_01v8  w=0.5  l=0.5
X_rhebb_3_27  iwrite_route_3_27  inp_upper_27  ierr_dig_3  vcm_route  vdd vss  hebbian_mult
XMPRED_r_3_28  i_pred_3  vw_route_3_28  vss  vss  sky130_fd_pr__nfet_01v8  w=4  l=0.35
Cw_route_3_28  vw_route_3_28  vss  200f
R_bleed_3_28  vw_route_3_28  vss  10000meg
XMN4_r_3_28  vw_route_3_28  we_route  iwrite_route_3_28  vss  sky130_fd_pr__nfet_01v8  w=0.5  l=0.5
X_rhebb_3_28  iwrite_route_3_28  inp_upper_28  ierr_dig_3  vcm_route  vdd vss  hebbian_mult
XMPRED_r_3_29  i_pred_3  vw_route_3_29  vss  vss  sky130_fd_pr__nfet_01v8  w=4  l=0.35
Cw_route_3_29  vw_route_3_29  vss  200f
R_bleed_3_29  vw_route_3_29  vss  10000meg
XMN4_r_3_29  vw_route_3_29  we_route  iwrite_route_3_29  vss  sky130_fd_pr__nfet_01v8  w=0.5  l=0.5
X_rhebb_3_29  iwrite_route_3_29  inp_upper_29  ierr_dig_3  vcm_route  vdd vss  hebbian_mult
XMPRED_r_3_30  i_pred_3  vw_route_3_30  vss  vss  sky130_fd_pr__nfet_01v8  w=4  l=0.35
Cw_route_3_30  vw_route_3_30  vss  200f
R_bleed_3_30  vw_route_3_30  vss  10000meg
XMN4_r_3_30  vw_route_3_30  we_route  iwrite_route_3_30  vss  sky130_fd_pr__nfet_01v8  w=0.5  l=0.5
X_rhebb_3_30  iwrite_route_3_30  inp_upper_30  ierr_dig_3  vcm_route  vdd vss  hebbian_mult
XMPRED_r_3_31  i_pred_3  vw_route_3_31  vss  vss  sky130_fd_pr__nfet_01v8  w=4  l=0.35
Cw_route_3_31  vw_route_3_31  vss  200f
R_bleed_3_31  vw_route_3_31  vss  10000meg
XMN4_r_3_31  vw_route_3_31  we_route  iwrite_route_3_31  vss  sky130_fd_pr__nfet_01v8  w=0.5  l=0.5
X_rhebb_3_31  iwrite_route_3_31  inp_upper_31  ierr_dig_3  vcm_route  vdd vss  hebbian_mult

* ── Destination row 4 ── 32 source connections ──────────────────────────
XMPRED_r_4_0  i_pred_4  vw_route_4_0  vss  vss  sky130_fd_pr__nfet_01v8  w=4  l=0.35
Cw_route_4_0  vw_route_4_0  vss  200f
R_bleed_4_0  vw_route_4_0  vss  10000meg
XMN4_r_4_0  vw_route_4_0  we_route  iwrite_route_4_0  vss  sky130_fd_pr__nfet_01v8  w=0.5  l=0.5
X_rhebb_4_0  iwrite_route_4_0  inp_upper_0  ierr_dig_4  vcm_route  vdd vss  hebbian_mult
XMPRED_r_4_1  i_pred_4  vw_route_4_1  vss  vss  sky130_fd_pr__nfet_01v8  w=4  l=0.35
Cw_route_4_1  vw_route_4_1  vss  200f
R_bleed_4_1  vw_route_4_1  vss  10000meg
XMN4_r_4_1  vw_route_4_1  we_route  iwrite_route_4_1  vss  sky130_fd_pr__nfet_01v8  w=0.5  l=0.5
X_rhebb_4_1  iwrite_route_4_1  inp_upper_1  ierr_dig_4  vcm_route  vdd vss  hebbian_mult
XMPRED_r_4_2  i_pred_4  vw_route_4_2  vss  vss  sky130_fd_pr__nfet_01v8  w=4  l=0.35
Cw_route_4_2  vw_route_4_2  vss  200f
R_bleed_4_2  vw_route_4_2  vss  10000meg
XMN4_r_4_2  vw_route_4_2  we_route  iwrite_route_4_2  vss  sky130_fd_pr__nfet_01v8  w=0.5  l=0.5
X_rhebb_4_2  iwrite_route_4_2  inp_upper_2  ierr_dig_4  vcm_route  vdd vss  hebbian_mult
XMPRED_r_4_3  i_pred_4  vw_route_4_3  vss  vss  sky130_fd_pr__nfet_01v8  w=4  l=0.35
Cw_route_4_3  vw_route_4_3  vss  200f
R_bleed_4_3  vw_route_4_3  vss  10000meg
XMN4_r_4_3  vw_route_4_3  we_route  iwrite_route_4_3  vss  sky130_fd_pr__nfet_01v8  w=0.5  l=0.5
X_rhebb_4_3  iwrite_route_4_3  inp_upper_3  ierr_dig_4  vcm_route  vdd vss  hebbian_mult
XMPRED_r_4_4  i_pred_4  vw_route_4_4  vss  vss  sky130_fd_pr__nfet_01v8  w=4  l=0.35
Cw_route_4_4  vw_route_4_4  vss  200f
R_bleed_4_4  vw_route_4_4  vss  10000meg
XMN4_r_4_4  vw_route_4_4  we_route  iwrite_route_4_4  vss  sky130_fd_pr__nfet_01v8  w=0.5  l=0.5
X_rhebb_4_4  iwrite_route_4_4  inp_upper_4  ierr_dig_4  vcm_route  vdd vss  hebbian_mult
XMPRED_r_4_5  i_pred_4  vw_route_4_5  vss  vss  sky130_fd_pr__nfet_01v8  w=4  l=0.35
Cw_route_4_5  vw_route_4_5  vss  200f
R_bleed_4_5  vw_route_4_5  vss  10000meg
XMN4_r_4_5  vw_route_4_5  we_route  iwrite_route_4_5  vss  sky130_fd_pr__nfet_01v8  w=0.5  l=0.5
X_rhebb_4_5  iwrite_route_4_5  inp_upper_5  ierr_dig_4  vcm_route  vdd vss  hebbian_mult
XMPRED_r_4_6  i_pred_4  vw_route_4_6  vss  vss  sky130_fd_pr__nfet_01v8  w=4  l=0.35
Cw_route_4_6  vw_route_4_6  vss  200f
R_bleed_4_6  vw_route_4_6  vss  10000meg
XMN4_r_4_6  vw_route_4_6  we_route  iwrite_route_4_6  vss  sky130_fd_pr__nfet_01v8  w=0.5  l=0.5
X_rhebb_4_6  iwrite_route_4_6  inp_upper_6  ierr_dig_4  vcm_route  vdd vss  hebbian_mult
XMPRED_r_4_7  i_pred_4  vw_route_4_7  vss  vss  sky130_fd_pr__nfet_01v8  w=4  l=0.35
Cw_route_4_7  vw_route_4_7  vss  200f
R_bleed_4_7  vw_route_4_7  vss  10000meg
XMN4_r_4_7  vw_route_4_7  we_route  iwrite_route_4_7  vss  sky130_fd_pr__nfet_01v8  w=0.5  l=0.5
X_rhebb_4_7  iwrite_route_4_7  inp_upper_7  ierr_dig_4  vcm_route  vdd vss  hebbian_mult
XMPRED_r_4_8  i_pred_4  vw_route_4_8  vss  vss  sky130_fd_pr__nfet_01v8  w=4  l=0.35
Cw_route_4_8  vw_route_4_8  vss  200f
R_bleed_4_8  vw_route_4_8  vss  10000meg
XMN4_r_4_8  vw_route_4_8  we_route  iwrite_route_4_8  vss  sky130_fd_pr__nfet_01v8  w=0.5  l=0.5
X_rhebb_4_8  iwrite_route_4_8  inp_upper_8  ierr_dig_4  vcm_route  vdd vss  hebbian_mult
XMPRED_r_4_9  i_pred_4  vw_route_4_9  vss  vss  sky130_fd_pr__nfet_01v8  w=4  l=0.35
Cw_route_4_9  vw_route_4_9  vss  200f
R_bleed_4_9  vw_route_4_9  vss  10000meg
XMN4_r_4_9  vw_route_4_9  we_route  iwrite_route_4_9  vss  sky130_fd_pr__nfet_01v8  w=0.5  l=0.5
X_rhebb_4_9  iwrite_route_4_9  inp_upper_9  ierr_dig_4  vcm_route  vdd vss  hebbian_mult
XMPRED_r_4_10  i_pred_4  vw_route_4_10  vss  vss  sky130_fd_pr__nfet_01v8  w=4  l=0.35
Cw_route_4_10  vw_route_4_10  vss  200f
R_bleed_4_10  vw_route_4_10  vss  10000meg
XMN4_r_4_10  vw_route_4_10  we_route  iwrite_route_4_10  vss  sky130_fd_pr__nfet_01v8  w=0.5  l=0.5
X_rhebb_4_10  iwrite_route_4_10  inp_upper_10  ierr_dig_4  vcm_route  vdd vss  hebbian_mult
XMPRED_r_4_11  i_pred_4  vw_route_4_11  vss  vss  sky130_fd_pr__nfet_01v8  w=4  l=0.35
Cw_route_4_11  vw_route_4_11  vss  200f
R_bleed_4_11  vw_route_4_11  vss  10000meg
XMN4_r_4_11  vw_route_4_11  we_route  iwrite_route_4_11  vss  sky130_fd_pr__nfet_01v8  w=0.5  l=0.5
X_rhebb_4_11  iwrite_route_4_11  inp_upper_11  ierr_dig_4  vcm_route  vdd vss  hebbian_mult
XMPRED_r_4_12  i_pred_4  vw_route_4_12  vss  vss  sky130_fd_pr__nfet_01v8  w=4  l=0.35
Cw_route_4_12  vw_route_4_12  vss  200f
R_bleed_4_12  vw_route_4_12  vss  10000meg
XMN4_r_4_12  vw_route_4_12  we_route  iwrite_route_4_12  vss  sky130_fd_pr__nfet_01v8  w=0.5  l=0.5
X_rhebb_4_12  iwrite_route_4_12  inp_upper_12  ierr_dig_4  vcm_route  vdd vss  hebbian_mult
XMPRED_r_4_13  i_pred_4  vw_route_4_13  vss  vss  sky130_fd_pr__nfet_01v8  w=4  l=0.35
Cw_route_4_13  vw_route_4_13  vss  200f
R_bleed_4_13  vw_route_4_13  vss  10000meg
XMN4_r_4_13  vw_route_4_13  we_route  iwrite_route_4_13  vss  sky130_fd_pr__nfet_01v8  w=0.5  l=0.5
X_rhebb_4_13  iwrite_route_4_13  inp_upper_13  ierr_dig_4  vcm_route  vdd vss  hebbian_mult
XMPRED_r_4_14  i_pred_4  vw_route_4_14  vss  vss  sky130_fd_pr__nfet_01v8  w=4  l=0.35
Cw_route_4_14  vw_route_4_14  vss  200f
R_bleed_4_14  vw_route_4_14  vss  10000meg
XMN4_r_4_14  vw_route_4_14  we_route  iwrite_route_4_14  vss  sky130_fd_pr__nfet_01v8  w=0.5  l=0.5
X_rhebb_4_14  iwrite_route_4_14  inp_upper_14  ierr_dig_4  vcm_route  vdd vss  hebbian_mult
XMPRED_r_4_15  i_pred_4  vw_route_4_15  vss  vss  sky130_fd_pr__nfet_01v8  w=4  l=0.35
Cw_route_4_15  vw_route_4_15  vss  200f
R_bleed_4_15  vw_route_4_15  vss  10000meg
XMN4_r_4_15  vw_route_4_15  we_route  iwrite_route_4_15  vss  sky130_fd_pr__nfet_01v8  w=0.5  l=0.5
X_rhebb_4_15  iwrite_route_4_15  inp_upper_15  ierr_dig_4  vcm_route  vdd vss  hebbian_mult
XMPRED_r_4_16  i_pred_4  vw_route_4_16  vss  vss  sky130_fd_pr__nfet_01v8  w=4  l=0.35
Cw_route_4_16  vw_route_4_16  vss  200f
R_bleed_4_16  vw_route_4_16  vss  10000meg
XMN4_r_4_16  vw_route_4_16  we_route  iwrite_route_4_16  vss  sky130_fd_pr__nfet_01v8  w=0.5  l=0.5
X_rhebb_4_16  iwrite_route_4_16  inp_upper_16  ierr_dig_4  vcm_route  vdd vss  hebbian_mult
XMPRED_r_4_17  i_pred_4  vw_route_4_17  vss  vss  sky130_fd_pr__nfet_01v8  w=4  l=0.35
Cw_route_4_17  vw_route_4_17  vss  200f
R_bleed_4_17  vw_route_4_17  vss  10000meg
XMN4_r_4_17  vw_route_4_17  we_route  iwrite_route_4_17  vss  sky130_fd_pr__nfet_01v8  w=0.5  l=0.5
X_rhebb_4_17  iwrite_route_4_17  inp_upper_17  ierr_dig_4  vcm_route  vdd vss  hebbian_mult
XMPRED_r_4_18  i_pred_4  vw_route_4_18  vss  vss  sky130_fd_pr__nfet_01v8  w=4  l=0.35
Cw_route_4_18  vw_route_4_18  vss  200f
R_bleed_4_18  vw_route_4_18  vss  10000meg
XMN4_r_4_18  vw_route_4_18  we_route  iwrite_route_4_18  vss  sky130_fd_pr__nfet_01v8  w=0.5  l=0.5
X_rhebb_4_18  iwrite_route_4_18  inp_upper_18  ierr_dig_4  vcm_route  vdd vss  hebbian_mult
XMPRED_r_4_19  i_pred_4  vw_route_4_19  vss  vss  sky130_fd_pr__nfet_01v8  w=4  l=0.35
Cw_route_4_19  vw_route_4_19  vss  200f
R_bleed_4_19  vw_route_4_19  vss  10000meg
XMN4_r_4_19  vw_route_4_19  we_route  iwrite_route_4_19  vss  sky130_fd_pr__nfet_01v8  w=0.5  l=0.5
X_rhebb_4_19  iwrite_route_4_19  inp_upper_19  ierr_dig_4  vcm_route  vdd vss  hebbian_mult
XMPRED_r_4_20  i_pred_4  vw_route_4_20  vss  vss  sky130_fd_pr__nfet_01v8  w=4  l=0.35
Cw_route_4_20  vw_route_4_20  vss  200f
R_bleed_4_20  vw_route_4_20  vss  10000meg
XMN4_r_4_20  vw_route_4_20  we_route  iwrite_route_4_20  vss  sky130_fd_pr__nfet_01v8  w=0.5  l=0.5
X_rhebb_4_20  iwrite_route_4_20  inp_upper_20  ierr_dig_4  vcm_route  vdd vss  hebbian_mult
XMPRED_r_4_21  i_pred_4  vw_route_4_21  vss  vss  sky130_fd_pr__nfet_01v8  w=4  l=0.35
Cw_route_4_21  vw_route_4_21  vss  200f
R_bleed_4_21  vw_route_4_21  vss  10000meg
XMN4_r_4_21  vw_route_4_21  we_route  iwrite_route_4_21  vss  sky130_fd_pr__nfet_01v8  w=0.5  l=0.5
X_rhebb_4_21  iwrite_route_4_21  inp_upper_21  ierr_dig_4  vcm_route  vdd vss  hebbian_mult
XMPRED_r_4_22  i_pred_4  vw_route_4_22  vss  vss  sky130_fd_pr__nfet_01v8  w=4  l=0.35
Cw_route_4_22  vw_route_4_22  vss  200f
R_bleed_4_22  vw_route_4_22  vss  10000meg
XMN4_r_4_22  vw_route_4_22  we_route  iwrite_route_4_22  vss  sky130_fd_pr__nfet_01v8  w=0.5  l=0.5
X_rhebb_4_22  iwrite_route_4_22  inp_upper_22  ierr_dig_4  vcm_route  vdd vss  hebbian_mult
XMPRED_r_4_23  i_pred_4  vw_route_4_23  vss  vss  sky130_fd_pr__nfet_01v8  w=4  l=0.35
Cw_route_4_23  vw_route_4_23  vss  200f
R_bleed_4_23  vw_route_4_23  vss  10000meg
XMN4_r_4_23  vw_route_4_23  we_route  iwrite_route_4_23  vss  sky130_fd_pr__nfet_01v8  w=0.5  l=0.5
X_rhebb_4_23  iwrite_route_4_23  inp_upper_23  ierr_dig_4  vcm_route  vdd vss  hebbian_mult
XMPRED_r_4_24  i_pred_4  vw_route_4_24  vss  vss  sky130_fd_pr__nfet_01v8  w=4  l=0.35
Cw_route_4_24  vw_route_4_24  vss  200f
R_bleed_4_24  vw_route_4_24  vss  10000meg
XMN4_r_4_24  vw_route_4_24  we_route  iwrite_route_4_24  vss  sky130_fd_pr__nfet_01v8  w=0.5  l=0.5
X_rhebb_4_24  iwrite_route_4_24  inp_upper_24  ierr_dig_4  vcm_route  vdd vss  hebbian_mult
XMPRED_r_4_25  i_pred_4  vw_route_4_25  vss  vss  sky130_fd_pr__nfet_01v8  w=4  l=0.35
Cw_route_4_25  vw_route_4_25  vss  200f
R_bleed_4_25  vw_route_4_25  vss  10000meg
XMN4_r_4_25  vw_route_4_25  we_route  iwrite_route_4_25  vss  sky130_fd_pr__nfet_01v8  w=0.5  l=0.5
X_rhebb_4_25  iwrite_route_4_25  inp_upper_25  ierr_dig_4  vcm_route  vdd vss  hebbian_mult
XMPRED_r_4_26  i_pred_4  vw_route_4_26  vss  vss  sky130_fd_pr__nfet_01v8  w=4  l=0.35
Cw_route_4_26  vw_route_4_26  vss  200f
R_bleed_4_26  vw_route_4_26  vss  10000meg
XMN4_r_4_26  vw_route_4_26  we_route  iwrite_route_4_26  vss  sky130_fd_pr__nfet_01v8  w=0.5  l=0.5
X_rhebb_4_26  iwrite_route_4_26  inp_upper_26  ierr_dig_4  vcm_route  vdd vss  hebbian_mult
XMPRED_r_4_27  i_pred_4  vw_route_4_27  vss  vss  sky130_fd_pr__nfet_01v8  w=4  l=0.35
Cw_route_4_27  vw_route_4_27  vss  200f
R_bleed_4_27  vw_route_4_27  vss  10000meg
XMN4_r_4_27  vw_route_4_27  we_route  iwrite_route_4_27  vss  sky130_fd_pr__nfet_01v8  w=0.5  l=0.5
X_rhebb_4_27  iwrite_route_4_27  inp_upper_27  ierr_dig_4  vcm_route  vdd vss  hebbian_mult
XMPRED_r_4_28  i_pred_4  vw_route_4_28  vss  vss  sky130_fd_pr__nfet_01v8  w=4  l=0.35
Cw_route_4_28  vw_route_4_28  vss  200f
R_bleed_4_28  vw_route_4_28  vss  10000meg
XMN4_r_4_28  vw_route_4_28  we_route  iwrite_route_4_28  vss  sky130_fd_pr__nfet_01v8  w=0.5  l=0.5
X_rhebb_4_28  iwrite_route_4_28  inp_upper_28  ierr_dig_4  vcm_route  vdd vss  hebbian_mult
XMPRED_r_4_29  i_pred_4  vw_route_4_29  vss  vss  sky130_fd_pr__nfet_01v8  w=4  l=0.35
Cw_route_4_29  vw_route_4_29  vss  200f
R_bleed_4_29  vw_route_4_29  vss  10000meg
XMN4_r_4_29  vw_route_4_29  we_route  iwrite_route_4_29  vss  sky130_fd_pr__nfet_01v8  w=0.5  l=0.5
X_rhebb_4_29  iwrite_route_4_29  inp_upper_29  ierr_dig_4  vcm_route  vdd vss  hebbian_mult
XMPRED_r_4_30  i_pred_4  vw_route_4_30  vss  vss  sky130_fd_pr__nfet_01v8  w=4  l=0.35
Cw_route_4_30  vw_route_4_30  vss  200f
R_bleed_4_30  vw_route_4_30  vss  10000meg
XMN4_r_4_30  vw_route_4_30  we_route  iwrite_route_4_30  vss  sky130_fd_pr__nfet_01v8  w=0.5  l=0.5
X_rhebb_4_30  iwrite_route_4_30  inp_upper_30  ierr_dig_4  vcm_route  vdd vss  hebbian_mult
XMPRED_r_4_31  i_pred_4  vw_route_4_31  vss  vss  sky130_fd_pr__nfet_01v8  w=4  l=0.35
Cw_route_4_31  vw_route_4_31  vss  200f
R_bleed_4_31  vw_route_4_31  vss  10000meg
XMN4_r_4_31  vw_route_4_31  we_route  iwrite_route_4_31  vss  sky130_fd_pr__nfet_01v8  w=0.5  l=0.5
X_rhebb_4_31  iwrite_route_4_31  inp_upper_31  ierr_dig_4  vcm_route  vdd vss  hebbian_mult

* ── Destination row 5 ── 32 source connections ──────────────────────────
XMPRED_r_5_0  i_pred_5  vw_route_5_0  vss  vss  sky130_fd_pr__nfet_01v8  w=4  l=0.35
Cw_route_5_0  vw_route_5_0  vss  200f
R_bleed_5_0  vw_route_5_0  vss  10000meg
XMN4_r_5_0  vw_route_5_0  we_route  iwrite_route_5_0  vss  sky130_fd_pr__nfet_01v8  w=0.5  l=0.5
X_rhebb_5_0  iwrite_route_5_0  inp_upper_0  ierr_dig_5  vcm_route  vdd vss  hebbian_mult
XMPRED_r_5_1  i_pred_5  vw_route_5_1  vss  vss  sky130_fd_pr__nfet_01v8  w=4  l=0.35
Cw_route_5_1  vw_route_5_1  vss  200f
R_bleed_5_1  vw_route_5_1  vss  10000meg
XMN4_r_5_1  vw_route_5_1  we_route  iwrite_route_5_1  vss  sky130_fd_pr__nfet_01v8  w=0.5  l=0.5
X_rhebb_5_1  iwrite_route_5_1  inp_upper_1  ierr_dig_5  vcm_route  vdd vss  hebbian_mult
XMPRED_r_5_2  i_pred_5  vw_route_5_2  vss  vss  sky130_fd_pr__nfet_01v8  w=4  l=0.35
Cw_route_5_2  vw_route_5_2  vss  200f
R_bleed_5_2  vw_route_5_2  vss  10000meg
XMN4_r_5_2  vw_route_5_2  we_route  iwrite_route_5_2  vss  sky130_fd_pr__nfet_01v8  w=0.5  l=0.5
X_rhebb_5_2  iwrite_route_5_2  inp_upper_2  ierr_dig_5  vcm_route  vdd vss  hebbian_mult
XMPRED_r_5_3  i_pred_5  vw_route_5_3  vss  vss  sky130_fd_pr__nfet_01v8  w=4  l=0.35
Cw_route_5_3  vw_route_5_3  vss  200f
R_bleed_5_3  vw_route_5_3  vss  10000meg
XMN4_r_5_3  vw_route_5_3  we_route  iwrite_route_5_3  vss  sky130_fd_pr__nfet_01v8  w=0.5  l=0.5
X_rhebb_5_3  iwrite_route_5_3  inp_upper_3  ierr_dig_5  vcm_route  vdd vss  hebbian_mult
XMPRED_r_5_4  i_pred_5  vw_route_5_4  vss  vss  sky130_fd_pr__nfet_01v8  w=4  l=0.35
Cw_route_5_4  vw_route_5_4  vss  200f
R_bleed_5_4  vw_route_5_4  vss  10000meg
XMN4_r_5_4  vw_route_5_4  we_route  iwrite_route_5_4  vss  sky130_fd_pr__nfet_01v8  w=0.5  l=0.5
X_rhebb_5_4  iwrite_route_5_4  inp_upper_4  ierr_dig_5  vcm_route  vdd vss  hebbian_mult
XMPRED_r_5_5  i_pred_5  vw_route_5_5  vss  vss  sky130_fd_pr__nfet_01v8  w=4  l=0.35
Cw_route_5_5  vw_route_5_5  vss  200f
R_bleed_5_5  vw_route_5_5  vss  10000meg
XMN4_r_5_5  vw_route_5_5  we_route  iwrite_route_5_5  vss  sky130_fd_pr__nfet_01v8  w=0.5  l=0.5
X_rhebb_5_5  iwrite_route_5_5  inp_upper_5  ierr_dig_5  vcm_route  vdd vss  hebbian_mult
XMPRED_r_5_6  i_pred_5  vw_route_5_6  vss  vss  sky130_fd_pr__nfet_01v8  w=4  l=0.35
Cw_route_5_6  vw_route_5_6  vss  200f
R_bleed_5_6  vw_route_5_6  vss  10000meg
XMN4_r_5_6  vw_route_5_6  we_route  iwrite_route_5_6  vss  sky130_fd_pr__nfet_01v8  w=0.5  l=0.5
X_rhebb_5_6  iwrite_route_5_6  inp_upper_6  ierr_dig_5  vcm_route  vdd vss  hebbian_mult
XMPRED_r_5_7  i_pred_5  vw_route_5_7  vss  vss  sky130_fd_pr__nfet_01v8  w=4  l=0.35
Cw_route_5_7  vw_route_5_7  vss  200f
R_bleed_5_7  vw_route_5_7  vss  10000meg
XMN4_r_5_7  vw_route_5_7  we_route  iwrite_route_5_7  vss  sky130_fd_pr__nfet_01v8  w=0.5  l=0.5
X_rhebb_5_7  iwrite_route_5_7  inp_upper_7  ierr_dig_5  vcm_route  vdd vss  hebbian_mult
XMPRED_r_5_8  i_pred_5  vw_route_5_8  vss  vss  sky130_fd_pr__nfet_01v8  w=4  l=0.35
Cw_route_5_8  vw_route_5_8  vss  200f
R_bleed_5_8  vw_route_5_8  vss  10000meg
XMN4_r_5_8  vw_route_5_8  we_route  iwrite_route_5_8  vss  sky130_fd_pr__nfet_01v8  w=0.5  l=0.5
X_rhebb_5_8  iwrite_route_5_8  inp_upper_8  ierr_dig_5  vcm_route  vdd vss  hebbian_mult
XMPRED_r_5_9  i_pred_5  vw_route_5_9  vss  vss  sky130_fd_pr__nfet_01v8  w=4  l=0.35
Cw_route_5_9  vw_route_5_9  vss  200f
R_bleed_5_9  vw_route_5_9  vss  10000meg
XMN4_r_5_9  vw_route_5_9  we_route  iwrite_route_5_9  vss  sky130_fd_pr__nfet_01v8  w=0.5  l=0.5
X_rhebb_5_9  iwrite_route_5_9  inp_upper_9  ierr_dig_5  vcm_route  vdd vss  hebbian_mult
XMPRED_r_5_10  i_pred_5  vw_route_5_10  vss  vss  sky130_fd_pr__nfet_01v8  w=4  l=0.35
Cw_route_5_10  vw_route_5_10  vss  200f
R_bleed_5_10  vw_route_5_10  vss  10000meg
XMN4_r_5_10  vw_route_5_10  we_route  iwrite_route_5_10  vss  sky130_fd_pr__nfet_01v8  w=0.5  l=0.5
X_rhebb_5_10  iwrite_route_5_10  inp_upper_10  ierr_dig_5  vcm_route  vdd vss  hebbian_mult
XMPRED_r_5_11  i_pred_5  vw_route_5_11  vss  vss  sky130_fd_pr__nfet_01v8  w=4  l=0.35
Cw_route_5_11  vw_route_5_11  vss  200f
R_bleed_5_11  vw_route_5_11  vss  10000meg
XMN4_r_5_11  vw_route_5_11  we_route  iwrite_route_5_11  vss  sky130_fd_pr__nfet_01v8  w=0.5  l=0.5
X_rhebb_5_11  iwrite_route_5_11  inp_upper_11  ierr_dig_5  vcm_route  vdd vss  hebbian_mult
XMPRED_r_5_12  i_pred_5  vw_route_5_12  vss  vss  sky130_fd_pr__nfet_01v8  w=4  l=0.35
Cw_route_5_12  vw_route_5_12  vss  200f
R_bleed_5_12  vw_route_5_12  vss  10000meg
XMN4_r_5_12  vw_route_5_12  we_route  iwrite_route_5_12  vss  sky130_fd_pr__nfet_01v8  w=0.5  l=0.5
X_rhebb_5_12  iwrite_route_5_12  inp_upper_12  ierr_dig_5  vcm_route  vdd vss  hebbian_mult
XMPRED_r_5_13  i_pred_5  vw_route_5_13  vss  vss  sky130_fd_pr__nfet_01v8  w=4  l=0.35
Cw_route_5_13  vw_route_5_13  vss  200f
R_bleed_5_13  vw_route_5_13  vss  10000meg
XMN4_r_5_13  vw_route_5_13  we_route  iwrite_route_5_13  vss  sky130_fd_pr__nfet_01v8  w=0.5  l=0.5
X_rhebb_5_13  iwrite_route_5_13  inp_upper_13  ierr_dig_5  vcm_route  vdd vss  hebbian_mult
XMPRED_r_5_14  i_pred_5  vw_route_5_14  vss  vss  sky130_fd_pr__nfet_01v8  w=4  l=0.35
Cw_route_5_14  vw_route_5_14  vss  200f
R_bleed_5_14  vw_route_5_14  vss  10000meg
XMN4_r_5_14  vw_route_5_14  we_route  iwrite_route_5_14  vss  sky130_fd_pr__nfet_01v8  w=0.5  l=0.5
X_rhebb_5_14  iwrite_route_5_14  inp_upper_14  ierr_dig_5  vcm_route  vdd vss  hebbian_mult
XMPRED_r_5_15  i_pred_5  vw_route_5_15  vss  vss  sky130_fd_pr__nfet_01v8  w=4  l=0.35
Cw_route_5_15  vw_route_5_15  vss  200f
R_bleed_5_15  vw_route_5_15  vss  10000meg
XMN4_r_5_15  vw_route_5_15  we_route  iwrite_route_5_15  vss  sky130_fd_pr__nfet_01v8  w=0.5  l=0.5
X_rhebb_5_15  iwrite_route_5_15  inp_upper_15  ierr_dig_5  vcm_route  vdd vss  hebbian_mult
XMPRED_r_5_16  i_pred_5  vw_route_5_16  vss  vss  sky130_fd_pr__nfet_01v8  w=4  l=0.35
Cw_route_5_16  vw_route_5_16  vss  200f
R_bleed_5_16  vw_route_5_16  vss  10000meg
XMN4_r_5_16  vw_route_5_16  we_route  iwrite_route_5_16  vss  sky130_fd_pr__nfet_01v8  w=0.5  l=0.5
X_rhebb_5_16  iwrite_route_5_16  inp_upper_16  ierr_dig_5  vcm_route  vdd vss  hebbian_mult
XMPRED_r_5_17  i_pred_5  vw_route_5_17  vss  vss  sky130_fd_pr__nfet_01v8  w=4  l=0.35
Cw_route_5_17  vw_route_5_17  vss  200f
R_bleed_5_17  vw_route_5_17  vss  10000meg
XMN4_r_5_17  vw_route_5_17  we_route  iwrite_route_5_17  vss  sky130_fd_pr__nfet_01v8  w=0.5  l=0.5
X_rhebb_5_17  iwrite_route_5_17  inp_upper_17  ierr_dig_5  vcm_route  vdd vss  hebbian_mult
XMPRED_r_5_18  i_pred_5  vw_route_5_18  vss  vss  sky130_fd_pr__nfet_01v8  w=4  l=0.35
Cw_route_5_18  vw_route_5_18  vss  200f
R_bleed_5_18  vw_route_5_18  vss  10000meg
XMN4_r_5_18  vw_route_5_18  we_route  iwrite_route_5_18  vss  sky130_fd_pr__nfet_01v8  w=0.5  l=0.5
X_rhebb_5_18  iwrite_route_5_18  inp_upper_18  ierr_dig_5  vcm_route  vdd vss  hebbian_mult
XMPRED_r_5_19  i_pred_5  vw_route_5_19  vss  vss  sky130_fd_pr__nfet_01v8  w=4  l=0.35
Cw_route_5_19  vw_route_5_19  vss  200f
R_bleed_5_19  vw_route_5_19  vss  10000meg
XMN4_r_5_19  vw_route_5_19  we_route  iwrite_route_5_19  vss  sky130_fd_pr__nfet_01v8  w=0.5  l=0.5
X_rhebb_5_19  iwrite_route_5_19  inp_upper_19  ierr_dig_5  vcm_route  vdd vss  hebbian_mult
XMPRED_r_5_20  i_pred_5  vw_route_5_20  vss  vss  sky130_fd_pr__nfet_01v8  w=4  l=0.35
Cw_route_5_20  vw_route_5_20  vss  200f
R_bleed_5_20  vw_route_5_20  vss  10000meg
XMN4_r_5_20  vw_route_5_20  we_route  iwrite_route_5_20  vss  sky130_fd_pr__nfet_01v8  w=0.5  l=0.5
X_rhebb_5_20  iwrite_route_5_20  inp_upper_20  ierr_dig_5  vcm_route  vdd vss  hebbian_mult
XMPRED_r_5_21  i_pred_5  vw_route_5_21  vss  vss  sky130_fd_pr__nfet_01v8  w=4  l=0.35
Cw_route_5_21  vw_route_5_21  vss  200f
R_bleed_5_21  vw_route_5_21  vss  10000meg
XMN4_r_5_21  vw_route_5_21  we_route  iwrite_route_5_21  vss  sky130_fd_pr__nfet_01v8  w=0.5  l=0.5
X_rhebb_5_21  iwrite_route_5_21  inp_upper_21  ierr_dig_5  vcm_route  vdd vss  hebbian_mult
XMPRED_r_5_22  i_pred_5  vw_route_5_22  vss  vss  sky130_fd_pr__nfet_01v8  w=4  l=0.35
Cw_route_5_22  vw_route_5_22  vss  200f
R_bleed_5_22  vw_route_5_22  vss  10000meg
XMN4_r_5_22  vw_route_5_22  we_route  iwrite_route_5_22  vss  sky130_fd_pr__nfet_01v8  w=0.5  l=0.5
X_rhebb_5_22  iwrite_route_5_22  inp_upper_22  ierr_dig_5  vcm_route  vdd vss  hebbian_mult
XMPRED_r_5_23  i_pred_5  vw_route_5_23  vss  vss  sky130_fd_pr__nfet_01v8  w=4  l=0.35
Cw_route_5_23  vw_route_5_23  vss  200f
R_bleed_5_23  vw_route_5_23  vss  10000meg
XMN4_r_5_23  vw_route_5_23  we_route  iwrite_route_5_23  vss  sky130_fd_pr__nfet_01v8  w=0.5  l=0.5
X_rhebb_5_23  iwrite_route_5_23  inp_upper_23  ierr_dig_5  vcm_route  vdd vss  hebbian_mult
XMPRED_r_5_24  i_pred_5  vw_route_5_24  vss  vss  sky130_fd_pr__nfet_01v8  w=4  l=0.35
Cw_route_5_24  vw_route_5_24  vss  200f
R_bleed_5_24  vw_route_5_24  vss  10000meg
XMN4_r_5_24  vw_route_5_24  we_route  iwrite_route_5_24  vss  sky130_fd_pr__nfet_01v8  w=0.5  l=0.5
X_rhebb_5_24  iwrite_route_5_24  inp_upper_24  ierr_dig_5  vcm_route  vdd vss  hebbian_mult
XMPRED_r_5_25  i_pred_5  vw_route_5_25  vss  vss  sky130_fd_pr__nfet_01v8  w=4  l=0.35
Cw_route_5_25  vw_route_5_25  vss  200f
R_bleed_5_25  vw_route_5_25  vss  10000meg
XMN4_r_5_25  vw_route_5_25  we_route  iwrite_route_5_25  vss  sky130_fd_pr__nfet_01v8  w=0.5  l=0.5
X_rhebb_5_25  iwrite_route_5_25  inp_upper_25  ierr_dig_5  vcm_route  vdd vss  hebbian_mult
XMPRED_r_5_26  i_pred_5  vw_route_5_26  vss  vss  sky130_fd_pr__nfet_01v8  w=4  l=0.35
Cw_route_5_26  vw_route_5_26  vss  200f
R_bleed_5_26  vw_route_5_26  vss  10000meg
XMN4_r_5_26  vw_route_5_26  we_route  iwrite_route_5_26  vss  sky130_fd_pr__nfet_01v8  w=0.5  l=0.5
X_rhebb_5_26  iwrite_route_5_26  inp_upper_26  ierr_dig_5  vcm_route  vdd vss  hebbian_mult
XMPRED_r_5_27  i_pred_5  vw_route_5_27  vss  vss  sky130_fd_pr__nfet_01v8  w=4  l=0.35
Cw_route_5_27  vw_route_5_27  vss  200f
R_bleed_5_27  vw_route_5_27  vss  10000meg
XMN4_r_5_27  vw_route_5_27  we_route  iwrite_route_5_27  vss  sky130_fd_pr__nfet_01v8  w=0.5  l=0.5
X_rhebb_5_27  iwrite_route_5_27  inp_upper_27  ierr_dig_5  vcm_route  vdd vss  hebbian_mult
XMPRED_r_5_28  i_pred_5  vw_route_5_28  vss  vss  sky130_fd_pr__nfet_01v8  w=4  l=0.35
Cw_route_5_28  vw_route_5_28  vss  200f
R_bleed_5_28  vw_route_5_28  vss  10000meg
XMN4_r_5_28  vw_route_5_28  we_route  iwrite_route_5_28  vss  sky130_fd_pr__nfet_01v8  w=0.5  l=0.5
X_rhebb_5_28  iwrite_route_5_28  inp_upper_28  ierr_dig_5  vcm_route  vdd vss  hebbian_mult
XMPRED_r_5_29  i_pred_5  vw_route_5_29  vss  vss  sky130_fd_pr__nfet_01v8  w=4  l=0.35
Cw_route_5_29  vw_route_5_29  vss  200f
R_bleed_5_29  vw_route_5_29  vss  10000meg
XMN4_r_5_29  vw_route_5_29  we_route  iwrite_route_5_29  vss  sky130_fd_pr__nfet_01v8  w=0.5  l=0.5
X_rhebb_5_29  iwrite_route_5_29  inp_upper_29  ierr_dig_5  vcm_route  vdd vss  hebbian_mult
XMPRED_r_5_30  i_pred_5  vw_route_5_30  vss  vss  sky130_fd_pr__nfet_01v8  w=4  l=0.35
Cw_route_5_30  vw_route_5_30  vss  200f
R_bleed_5_30  vw_route_5_30  vss  10000meg
XMN4_r_5_30  vw_route_5_30  we_route  iwrite_route_5_30  vss  sky130_fd_pr__nfet_01v8  w=0.5  l=0.5
X_rhebb_5_30  iwrite_route_5_30  inp_upper_30  ierr_dig_5  vcm_route  vdd vss  hebbian_mult
XMPRED_r_5_31  i_pred_5  vw_route_5_31  vss  vss  sky130_fd_pr__nfet_01v8  w=4  l=0.35
Cw_route_5_31  vw_route_5_31  vss  200f
R_bleed_5_31  vw_route_5_31  vss  10000meg
XMN4_r_5_31  vw_route_5_31  we_route  iwrite_route_5_31  vss  sky130_fd_pr__nfet_01v8  w=0.5  l=0.5
X_rhebb_5_31  iwrite_route_5_31  inp_upper_31  ierr_dig_5  vcm_route  vdd vss  hebbian_mult

* ── Destination row 6 ── 32 source connections ──────────────────────────
XMPRED_r_6_0  i_pred_6  vw_route_6_0  vss  vss  sky130_fd_pr__nfet_01v8  w=4  l=0.35
Cw_route_6_0  vw_route_6_0  vss  200f
R_bleed_6_0  vw_route_6_0  vss  10000meg
XMN4_r_6_0  vw_route_6_0  we_route  iwrite_route_6_0  vss  sky130_fd_pr__nfet_01v8  w=0.5  l=0.5
X_rhebb_6_0  iwrite_route_6_0  inp_upper_0  ierr_dig_6  vcm_route  vdd vss  hebbian_mult
XMPRED_r_6_1  i_pred_6  vw_route_6_1  vss  vss  sky130_fd_pr__nfet_01v8  w=4  l=0.35
Cw_route_6_1  vw_route_6_1  vss  200f
R_bleed_6_1  vw_route_6_1  vss  10000meg
XMN4_r_6_1  vw_route_6_1  we_route  iwrite_route_6_1  vss  sky130_fd_pr__nfet_01v8  w=0.5  l=0.5
X_rhebb_6_1  iwrite_route_6_1  inp_upper_1  ierr_dig_6  vcm_route  vdd vss  hebbian_mult
XMPRED_r_6_2  i_pred_6  vw_route_6_2  vss  vss  sky130_fd_pr__nfet_01v8  w=4  l=0.35
Cw_route_6_2  vw_route_6_2  vss  200f
R_bleed_6_2  vw_route_6_2  vss  10000meg
XMN4_r_6_2  vw_route_6_2  we_route  iwrite_route_6_2  vss  sky130_fd_pr__nfet_01v8  w=0.5  l=0.5
X_rhebb_6_2  iwrite_route_6_2  inp_upper_2  ierr_dig_6  vcm_route  vdd vss  hebbian_mult
XMPRED_r_6_3  i_pred_6  vw_route_6_3  vss  vss  sky130_fd_pr__nfet_01v8  w=4  l=0.35
Cw_route_6_3  vw_route_6_3  vss  200f
R_bleed_6_3  vw_route_6_3  vss  10000meg
XMN4_r_6_3  vw_route_6_3  we_route  iwrite_route_6_3  vss  sky130_fd_pr__nfet_01v8  w=0.5  l=0.5
X_rhebb_6_3  iwrite_route_6_3  inp_upper_3  ierr_dig_6  vcm_route  vdd vss  hebbian_mult
XMPRED_r_6_4  i_pred_6  vw_route_6_4  vss  vss  sky130_fd_pr__nfet_01v8  w=4  l=0.35
Cw_route_6_4  vw_route_6_4  vss  200f
R_bleed_6_4  vw_route_6_4  vss  10000meg
XMN4_r_6_4  vw_route_6_4  we_route  iwrite_route_6_4  vss  sky130_fd_pr__nfet_01v8  w=0.5  l=0.5
X_rhebb_6_4  iwrite_route_6_4  inp_upper_4  ierr_dig_6  vcm_route  vdd vss  hebbian_mult
XMPRED_r_6_5  i_pred_6  vw_route_6_5  vss  vss  sky130_fd_pr__nfet_01v8  w=4  l=0.35
Cw_route_6_5  vw_route_6_5  vss  200f
R_bleed_6_5  vw_route_6_5  vss  10000meg
XMN4_r_6_5  vw_route_6_5  we_route  iwrite_route_6_5  vss  sky130_fd_pr__nfet_01v8  w=0.5  l=0.5
X_rhebb_6_5  iwrite_route_6_5  inp_upper_5  ierr_dig_6  vcm_route  vdd vss  hebbian_mult
XMPRED_r_6_6  i_pred_6  vw_route_6_6  vss  vss  sky130_fd_pr__nfet_01v8  w=4  l=0.35
Cw_route_6_6  vw_route_6_6  vss  200f
R_bleed_6_6  vw_route_6_6  vss  10000meg
XMN4_r_6_6  vw_route_6_6  we_route  iwrite_route_6_6  vss  sky130_fd_pr__nfet_01v8  w=0.5  l=0.5
X_rhebb_6_6  iwrite_route_6_6  inp_upper_6  ierr_dig_6  vcm_route  vdd vss  hebbian_mult
XMPRED_r_6_7  i_pred_6  vw_route_6_7  vss  vss  sky130_fd_pr__nfet_01v8  w=4  l=0.35
Cw_route_6_7  vw_route_6_7  vss  200f
R_bleed_6_7  vw_route_6_7  vss  10000meg
XMN4_r_6_7  vw_route_6_7  we_route  iwrite_route_6_7  vss  sky130_fd_pr__nfet_01v8  w=0.5  l=0.5
X_rhebb_6_7  iwrite_route_6_7  inp_upper_7  ierr_dig_6  vcm_route  vdd vss  hebbian_mult
XMPRED_r_6_8  i_pred_6  vw_route_6_8  vss  vss  sky130_fd_pr__nfet_01v8  w=4  l=0.35
Cw_route_6_8  vw_route_6_8  vss  200f
R_bleed_6_8  vw_route_6_8  vss  10000meg
XMN4_r_6_8  vw_route_6_8  we_route  iwrite_route_6_8  vss  sky130_fd_pr__nfet_01v8  w=0.5  l=0.5
X_rhebb_6_8  iwrite_route_6_8  inp_upper_8  ierr_dig_6  vcm_route  vdd vss  hebbian_mult
XMPRED_r_6_9  i_pred_6  vw_route_6_9  vss  vss  sky130_fd_pr__nfet_01v8  w=4  l=0.35
Cw_route_6_9  vw_route_6_9  vss  200f
R_bleed_6_9  vw_route_6_9  vss  10000meg
XMN4_r_6_9  vw_route_6_9  we_route  iwrite_route_6_9  vss  sky130_fd_pr__nfet_01v8  w=0.5  l=0.5
X_rhebb_6_9  iwrite_route_6_9  inp_upper_9  ierr_dig_6  vcm_route  vdd vss  hebbian_mult
XMPRED_r_6_10  i_pred_6  vw_route_6_10  vss  vss  sky130_fd_pr__nfet_01v8  w=4  l=0.35
Cw_route_6_10  vw_route_6_10  vss  200f
R_bleed_6_10  vw_route_6_10  vss  10000meg
XMN4_r_6_10  vw_route_6_10  we_route  iwrite_route_6_10  vss  sky130_fd_pr__nfet_01v8  w=0.5  l=0.5
X_rhebb_6_10  iwrite_route_6_10  inp_upper_10  ierr_dig_6  vcm_route  vdd vss  hebbian_mult
XMPRED_r_6_11  i_pred_6  vw_route_6_11  vss  vss  sky130_fd_pr__nfet_01v8  w=4  l=0.35
Cw_route_6_11  vw_route_6_11  vss  200f
R_bleed_6_11  vw_route_6_11  vss  10000meg
XMN4_r_6_11  vw_route_6_11  we_route  iwrite_route_6_11  vss  sky130_fd_pr__nfet_01v8  w=0.5  l=0.5
X_rhebb_6_11  iwrite_route_6_11  inp_upper_11  ierr_dig_6  vcm_route  vdd vss  hebbian_mult
XMPRED_r_6_12  i_pred_6  vw_route_6_12  vss  vss  sky130_fd_pr__nfet_01v8  w=4  l=0.35
Cw_route_6_12  vw_route_6_12  vss  200f
R_bleed_6_12  vw_route_6_12  vss  10000meg
XMN4_r_6_12  vw_route_6_12  we_route  iwrite_route_6_12  vss  sky130_fd_pr__nfet_01v8  w=0.5  l=0.5
X_rhebb_6_12  iwrite_route_6_12  inp_upper_12  ierr_dig_6  vcm_route  vdd vss  hebbian_mult
XMPRED_r_6_13  i_pred_6  vw_route_6_13  vss  vss  sky130_fd_pr__nfet_01v8  w=4  l=0.35
Cw_route_6_13  vw_route_6_13  vss  200f
R_bleed_6_13  vw_route_6_13  vss  10000meg
XMN4_r_6_13  vw_route_6_13  we_route  iwrite_route_6_13  vss  sky130_fd_pr__nfet_01v8  w=0.5  l=0.5
X_rhebb_6_13  iwrite_route_6_13  inp_upper_13  ierr_dig_6  vcm_route  vdd vss  hebbian_mult
XMPRED_r_6_14  i_pred_6  vw_route_6_14  vss  vss  sky130_fd_pr__nfet_01v8  w=4  l=0.35
Cw_route_6_14  vw_route_6_14  vss  200f
R_bleed_6_14  vw_route_6_14  vss  10000meg
XMN4_r_6_14  vw_route_6_14  we_route  iwrite_route_6_14  vss  sky130_fd_pr__nfet_01v8  w=0.5  l=0.5
X_rhebb_6_14  iwrite_route_6_14  inp_upper_14  ierr_dig_6  vcm_route  vdd vss  hebbian_mult
XMPRED_r_6_15  i_pred_6  vw_route_6_15  vss  vss  sky130_fd_pr__nfet_01v8  w=4  l=0.35
Cw_route_6_15  vw_route_6_15  vss  200f
R_bleed_6_15  vw_route_6_15  vss  10000meg
XMN4_r_6_15  vw_route_6_15  we_route  iwrite_route_6_15  vss  sky130_fd_pr__nfet_01v8  w=0.5  l=0.5
X_rhebb_6_15  iwrite_route_6_15  inp_upper_15  ierr_dig_6  vcm_route  vdd vss  hebbian_mult
XMPRED_r_6_16  i_pred_6  vw_route_6_16  vss  vss  sky130_fd_pr__nfet_01v8  w=4  l=0.35
Cw_route_6_16  vw_route_6_16  vss  200f
R_bleed_6_16  vw_route_6_16  vss  10000meg
XMN4_r_6_16  vw_route_6_16  we_route  iwrite_route_6_16  vss  sky130_fd_pr__nfet_01v8  w=0.5  l=0.5
X_rhebb_6_16  iwrite_route_6_16  inp_upper_16  ierr_dig_6  vcm_route  vdd vss  hebbian_mult
XMPRED_r_6_17  i_pred_6  vw_route_6_17  vss  vss  sky130_fd_pr__nfet_01v8  w=4  l=0.35
Cw_route_6_17  vw_route_6_17  vss  200f
R_bleed_6_17  vw_route_6_17  vss  10000meg
XMN4_r_6_17  vw_route_6_17  we_route  iwrite_route_6_17  vss  sky130_fd_pr__nfet_01v8  w=0.5  l=0.5
X_rhebb_6_17  iwrite_route_6_17  inp_upper_17  ierr_dig_6  vcm_route  vdd vss  hebbian_mult
XMPRED_r_6_18  i_pred_6  vw_route_6_18  vss  vss  sky130_fd_pr__nfet_01v8  w=4  l=0.35
Cw_route_6_18  vw_route_6_18  vss  200f
R_bleed_6_18  vw_route_6_18  vss  10000meg
XMN4_r_6_18  vw_route_6_18  we_route  iwrite_route_6_18  vss  sky130_fd_pr__nfet_01v8  w=0.5  l=0.5
X_rhebb_6_18  iwrite_route_6_18  inp_upper_18  ierr_dig_6  vcm_route  vdd vss  hebbian_mult
XMPRED_r_6_19  i_pred_6  vw_route_6_19  vss  vss  sky130_fd_pr__nfet_01v8  w=4  l=0.35
Cw_route_6_19  vw_route_6_19  vss  200f
R_bleed_6_19  vw_route_6_19  vss  10000meg
XMN4_r_6_19  vw_route_6_19  we_route  iwrite_route_6_19  vss  sky130_fd_pr__nfet_01v8  w=0.5  l=0.5
X_rhebb_6_19  iwrite_route_6_19  inp_upper_19  ierr_dig_6  vcm_route  vdd vss  hebbian_mult
XMPRED_r_6_20  i_pred_6  vw_route_6_20  vss  vss  sky130_fd_pr__nfet_01v8  w=4  l=0.35
Cw_route_6_20  vw_route_6_20  vss  200f
R_bleed_6_20  vw_route_6_20  vss  10000meg
XMN4_r_6_20  vw_route_6_20  we_route  iwrite_route_6_20  vss  sky130_fd_pr__nfet_01v8  w=0.5  l=0.5
X_rhebb_6_20  iwrite_route_6_20  inp_upper_20  ierr_dig_6  vcm_route  vdd vss  hebbian_mult
XMPRED_r_6_21  i_pred_6  vw_route_6_21  vss  vss  sky130_fd_pr__nfet_01v8  w=4  l=0.35
Cw_route_6_21  vw_route_6_21  vss  200f
R_bleed_6_21  vw_route_6_21  vss  10000meg
XMN4_r_6_21  vw_route_6_21  we_route  iwrite_route_6_21  vss  sky130_fd_pr__nfet_01v8  w=0.5  l=0.5
X_rhebb_6_21  iwrite_route_6_21  inp_upper_21  ierr_dig_6  vcm_route  vdd vss  hebbian_mult
XMPRED_r_6_22  i_pred_6  vw_route_6_22  vss  vss  sky130_fd_pr__nfet_01v8  w=4  l=0.35
Cw_route_6_22  vw_route_6_22  vss  200f
R_bleed_6_22  vw_route_6_22  vss  10000meg
XMN4_r_6_22  vw_route_6_22  we_route  iwrite_route_6_22  vss  sky130_fd_pr__nfet_01v8  w=0.5  l=0.5
X_rhebb_6_22  iwrite_route_6_22  inp_upper_22  ierr_dig_6  vcm_route  vdd vss  hebbian_mult
XMPRED_r_6_23  i_pred_6  vw_route_6_23  vss  vss  sky130_fd_pr__nfet_01v8  w=4  l=0.35
Cw_route_6_23  vw_route_6_23  vss  200f
R_bleed_6_23  vw_route_6_23  vss  10000meg
XMN4_r_6_23  vw_route_6_23  we_route  iwrite_route_6_23  vss  sky130_fd_pr__nfet_01v8  w=0.5  l=0.5
X_rhebb_6_23  iwrite_route_6_23  inp_upper_23  ierr_dig_6  vcm_route  vdd vss  hebbian_mult
XMPRED_r_6_24  i_pred_6  vw_route_6_24  vss  vss  sky130_fd_pr__nfet_01v8  w=4  l=0.35
Cw_route_6_24  vw_route_6_24  vss  200f
R_bleed_6_24  vw_route_6_24  vss  10000meg
XMN4_r_6_24  vw_route_6_24  we_route  iwrite_route_6_24  vss  sky130_fd_pr__nfet_01v8  w=0.5  l=0.5
X_rhebb_6_24  iwrite_route_6_24  inp_upper_24  ierr_dig_6  vcm_route  vdd vss  hebbian_mult
XMPRED_r_6_25  i_pred_6  vw_route_6_25  vss  vss  sky130_fd_pr__nfet_01v8  w=4  l=0.35
Cw_route_6_25  vw_route_6_25  vss  200f
R_bleed_6_25  vw_route_6_25  vss  10000meg
XMN4_r_6_25  vw_route_6_25  we_route  iwrite_route_6_25  vss  sky130_fd_pr__nfet_01v8  w=0.5  l=0.5
X_rhebb_6_25  iwrite_route_6_25  inp_upper_25  ierr_dig_6  vcm_route  vdd vss  hebbian_mult
XMPRED_r_6_26  i_pred_6  vw_route_6_26  vss  vss  sky130_fd_pr__nfet_01v8  w=4  l=0.35
Cw_route_6_26  vw_route_6_26  vss  200f
R_bleed_6_26  vw_route_6_26  vss  10000meg
XMN4_r_6_26  vw_route_6_26  we_route  iwrite_route_6_26  vss  sky130_fd_pr__nfet_01v8  w=0.5  l=0.5
X_rhebb_6_26  iwrite_route_6_26  inp_upper_26  ierr_dig_6  vcm_route  vdd vss  hebbian_mult
XMPRED_r_6_27  i_pred_6  vw_route_6_27  vss  vss  sky130_fd_pr__nfet_01v8  w=4  l=0.35
Cw_route_6_27  vw_route_6_27  vss  200f
R_bleed_6_27  vw_route_6_27  vss  10000meg
XMN4_r_6_27  vw_route_6_27  we_route  iwrite_route_6_27  vss  sky130_fd_pr__nfet_01v8  w=0.5  l=0.5
X_rhebb_6_27  iwrite_route_6_27  inp_upper_27  ierr_dig_6  vcm_route  vdd vss  hebbian_mult
XMPRED_r_6_28  i_pred_6  vw_route_6_28  vss  vss  sky130_fd_pr__nfet_01v8  w=4  l=0.35
Cw_route_6_28  vw_route_6_28  vss  200f
R_bleed_6_28  vw_route_6_28  vss  10000meg
XMN4_r_6_28  vw_route_6_28  we_route  iwrite_route_6_28  vss  sky130_fd_pr__nfet_01v8  w=0.5  l=0.5
X_rhebb_6_28  iwrite_route_6_28  inp_upper_28  ierr_dig_6  vcm_route  vdd vss  hebbian_mult
XMPRED_r_6_29  i_pred_6  vw_route_6_29  vss  vss  sky130_fd_pr__nfet_01v8  w=4  l=0.35
Cw_route_6_29  vw_route_6_29  vss  200f
R_bleed_6_29  vw_route_6_29  vss  10000meg
XMN4_r_6_29  vw_route_6_29  we_route  iwrite_route_6_29  vss  sky130_fd_pr__nfet_01v8  w=0.5  l=0.5
X_rhebb_6_29  iwrite_route_6_29  inp_upper_29  ierr_dig_6  vcm_route  vdd vss  hebbian_mult
XMPRED_r_6_30  i_pred_6  vw_route_6_30  vss  vss  sky130_fd_pr__nfet_01v8  w=4  l=0.35
Cw_route_6_30  vw_route_6_30  vss  200f
R_bleed_6_30  vw_route_6_30  vss  10000meg
XMN4_r_6_30  vw_route_6_30  we_route  iwrite_route_6_30  vss  sky130_fd_pr__nfet_01v8  w=0.5  l=0.5
X_rhebb_6_30  iwrite_route_6_30  inp_upper_30  ierr_dig_6  vcm_route  vdd vss  hebbian_mult
XMPRED_r_6_31  i_pred_6  vw_route_6_31  vss  vss  sky130_fd_pr__nfet_01v8  w=4  l=0.35
Cw_route_6_31  vw_route_6_31  vss  200f
R_bleed_6_31  vw_route_6_31  vss  10000meg
XMN4_r_6_31  vw_route_6_31  we_route  iwrite_route_6_31  vss  sky130_fd_pr__nfet_01v8  w=0.5  l=0.5
X_rhebb_6_31  iwrite_route_6_31  inp_upper_31  ierr_dig_6  vcm_route  vdd vss  hebbian_mult

* ── Destination row 7 ── 32 source connections ──────────────────────────
XMPRED_r_7_0  i_pred_7  vw_route_7_0  vss  vss  sky130_fd_pr__nfet_01v8  w=4  l=0.35
Cw_route_7_0  vw_route_7_0  vss  200f
R_bleed_7_0  vw_route_7_0  vss  10000meg
XMN4_r_7_0  vw_route_7_0  we_route  iwrite_route_7_0  vss  sky130_fd_pr__nfet_01v8  w=0.5  l=0.5
X_rhebb_7_0  iwrite_route_7_0  inp_upper_0  ierr_dig_7  vcm_route  vdd vss  hebbian_mult
XMPRED_r_7_1  i_pred_7  vw_route_7_1  vss  vss  sky130_fd_pr__nfet_01v8  w=4  l=0.35
Cw_route_7_1  vw_route_7_1  vss  200f
R_bleed_7_1  vw_route_7_1  vss  10000meg
XMN4_r_7_1  vw_route_7_1  we_route  iwrite_route_7_1  vss  sky130_fd_pr__nfet_01v8  w=0.5  l=0.5
X_rhebb_7_1  iwrite_route_7_1  inp_upper_1  ierr_dig_7  vcm_route  vdd vss  hebbian_mult
XMPRED_r_7_2  i_pred_7  vw_route_7_2  vss  vss  sky130_fd_pr__nfet_01v8  w=4  l=0.35
Cw_route_7_2  vw_route_7_2  vss  200f
R_bleed_7_2  vw_route_7_2  vss  10000meg
XMN4_r_7_2  vw_route_7_2  we_route  iwrite_route_7_2  vss  sky130_fd_pr__nfet_01v8  w=0.5  l=0.5
X_rhebb_7_2  iwrite_route_7_2  inp_upper_2  ierr_dig_7  vcm_route  vdd vss  hebbian_mult
XMPRED_r_7_3  i_pred_7  vw_route_7_3  vss  vss  sky130_fd_pr__nfet_01v8  w=4  l=0.35
Cw_route_7_3  vw_route_7_3  vss  200f
R_bleed_7_3  vw_route_7_3  vss  10000meg
XMN4_r_7_3  vw_route_7_3  we_route  iwrite_route_7_3  vss  sky130_fd_pr__nfet_01v8  w=0.5  l=0.5
X_rhebb_7_3  iwrite_route_7_3  inp_upper_3  ierr_dig_7  vcm_route  vdd vss  hebbian_mult
XMPRED_r_7_4  i_pred_7  vw_route_7_4  vss  vss  sky130_fd_pr__nfet_01v8  w=4  l=0.35
Cw_route_7_4  vw_route_7_4  vss  200f
R_bleed_7_4  vw_route_7_4  vss  10000meg
XMN4_r_7_4  vw_route_7_4  we_route  iwrite_route_7_4  vss  sky130_fd_pr__nfet_01v8  w=0.5  l=0.5
X_rhebb_7_4  iwrite_route_7_4  inp_upper_4  ierr_dig_7  vcm_route  vdd vss  hebbian_mult
XMPRED_r_7_5  i_pred_7  vw_route_7_5  vss  vss  sky130_fd_pr__nfet_01v8  w=4  l=0.35
Cw_route_7_5  vw_route_7_5  vss  200f
R_bleed_7_5  vw_route_7_5  vss  10000meg
XMN4_r_7_5  vw_route_7_5  we_route  iwrite_route_7_5  vss  sky130_fd_pr__nfet_01v8  w=0.5  l=0.5
X_rhebb_7_5  iwrite_route_7_5  inp_upper_5  ierr_dig_7  vcm_route  vdd vss  hebbian_mult
XMPRED_r_7_6  i_pred_7  vw_route_7_6  vss  vss  sky130_fd_pr__nfet_01v8  w=4  l=0.35
Cw_route_7_6  vw_route_7_6  vss  200f
R_bleed_7_6  vw_route_7_6  vss  10000meg
XMN4_r_7_6  vw_route_7_6  we_route  iwrite_route_7_6  vss  sky130_fd_pr__nfet_01v8  w=0.5  l=0.5
X_rhebb_7_6  iwrite_route_7_6  inp_upper_6  ierr_dig_7  vcm_route  vdd vss  hebbian_mult
XMPRED_r_7_7  i_pred_7  vw_route_7_7  vss  vss  sky130_fd_pr__nfet_01v8  w=4  l=0.35
Cw_route_7_7  vw_route_7_7  vss  200f
R_bleed_7_7  vw_route_7_7  vss  10000meg
XMN4_r_7_7  vw_route_7_7  we_route  iwrite_route_7_7  vss  sky130_fd_pr__nfet_01v8  w=0.5  l=0.5
X_rhebb_7_7  iwrite_route_7_7  inp_upper_7  ierr_dig_7  vcm_route  vdd vss  hebbian_mult
XMPRED_r_7_8  i_pred_7  vw_route_7_8  vss  vss  sky130_fd_pr__nfet_01v8  w=4  l=0.35
Cw_route_7_8  vw_route_7_8  vss  200f
R_bleed_7_8  vw_route_7_8  vss  10000meg
XMN4_r_7_8  vw_route_7_8  we_route  iwrite_route_7_8  vss  sky130_fd_pr__nfet_01v8  w=0.5  l=0.5
X_rhebb_7_8  iwrite_route_7_8  inp_upper_8  ierr_dig_7  vcm_route  vdd vss  hebbian_mult
XMPRED_r_7_9  i_pred_7  vw_route_7_9  vss  vss  sky130_fd_pr__nfet_01v8  w=4  l=0.35
Cw_route_7_9  vw_route_7_9  vss  200f
R_bleed_7_9  vw_route_7_9  vss  10000meg
XMN4_r_7_9  vw_route_7_9  we_route  iwrite_route_7_9  vss  sky130_fd_pr__nfet_01v8  w=0.5  l=0.5
X_rhebb_7_9  iwrite_route_7_9  inp_upper_9  ierr_dig_7  vcm_route  vdd vss  hebbian_mult
XMPRED_r_7_10  i_pred_7  vw_route_7_10  vss  vss  sky130_fd_pr__nfet_01v8  w=4  l=0.35
Cw_route_7_10  vw_route_7_10  vss  200f
R_bleed_7_10  vw_route_7_10  vss  10000meg
XMN4_r_7_10  vw_route_7_10  we_route  iwrite_route_7_10  vss  sky130_fd_pr__nfet_01v8  w=0.5  l=0.5
X_rhebb_7_10  iwrite_route_7_10  inp_upper_10  ierr_dig_7  vcm_route  vdd vss  hebbian_mult
XMPRED_r_7_11  i_pred_7  vw_route_7_11  vss  vss  sky130_fd_pr__nfet_01v8  w=4  l=0.35
Cw_route_7_11  vw_route_7_11  vss  200f
R_bleed_7_11  vw_route_7_11  vss  10000meg
XMN4_r_7_11  vw_route_7_11  we_route  iwrite_route_7_11  vss  sky130_fd_pr__nfet_01v8  w=0.5  l=0.5
X_rhebb_7_11  iwrite_route_7_11  inp_upper_11  ierr_dig_7  vcm_route  vdd vss  hebbian_mult
XMPRED_r_7_12  i_pred_7  vw_route_7_12  vss  vss  sky130_fd_pr__nfet_01v8  w=4  l=0.35
Cw_route_7_12  vw_route_7_12  vss  200f
R_bleed_7_12  vw_route_7_12  vss  10000meg
XMN4_r_7_12  vw_route_7_12  we_route  iwrite_route_7_12  vss  sky130_fd_pr__nfet_01v8  w=0.5  l=0.5
X_rhebb_7_12  iwrite_route_7_12  inp_upper_12  ierr_dig_7  vcm_route  vdd vss  hebbian_mult
XMPRED_r_7_13  i_pred_7  vw_route_7_13  vss  vss  sky130_fd_pr__nfet_01v8  w=4  l=0.35
Cw_route_7_13  vw_route_7_13  vss  200f
R_bleed_7_13  vw_route_7_13  vss  10000meg
XMN4_r_7_13  vw_route_7_13  we_route  iwrite_route_7_13  vss  sky130_fd_pr__nfet_01v8  w=0.5  l=0.5
X_rhebb_7_13  iwrite_route_7_13  inp_upper_13  ierr_dig_7  vcm_route  vdd vss  hebbian_mult
XMPRED_r_7_14  i_pred_7  vw_route_7_14  vss  vss  sky130_fd_pr__nfet_01v8  w=4  l=0.35
Cw_route_7_14  vw_route_7_14  vss  200f
R_bleed_7_14  vw_route_7_14  vss  10000meg
XMN4_r_7_14  vw_route_7_14  we_route  iwrite_route_7_14  vss  sky130_fd_pr__nfet_01v8  w=0.5  l=0.5
X_rhebb_7_14  iwrite_route_7_14  inp_upper_14  ierr_dig_7  vcm_route  vdd vss  hebbian_mult
XMPRED_r_7_15  i_pred_7  vw_route_7_15  vss  vss  sky130_fd_pr__nfet_01v8  w=4  l=0.35
Cw_route_7_15  vw_route_7_15  vss  200f
R_bleed_7_15  vw_route_7_15  vss  10000meg
XMN4_r_7_15  vw_route_7_15  we_route  iwrite_route_7_15  vss  sky130_fd_pr__nfet_01v8  w=0.5  l=0.5
X_rhebb_7_15  iwrite_route_7_15  inp_upper_15  ierr_dig_7  vcm_route  vdd vss  hebbian_mult
XMPRED_r_7_16  i_pred_7  vw_route_7_16  vss  vss  sky130_fd_pr__nfet_01v8  w=4  l=0.35
Cw_route_7_16  vw_route_7_16  vss  200f
R_bleed_7_16  vw_route_7_16  vss  10000meg
XMN4_r_7_16  vw_route_7_16  we_route  iwrite_route_7_16  vss  sky130_fd_pr__nfet_01v8  w=0.5  l=0.5
X_rhebb_7_16  iwrite_route_7_16  inp_upper_16  ierr_dig_7  vcm_route  vdd vss  hebbian_mult
XMPRED_r_7_17  i_pred_7  vw_route_7_17  vss  vss  sky130_fd_pr__nfet_01v8  w=4  l=0.35
Cw_route_7_17  vw_route_7_17  vss  200f
R_bleed_7_17  vw_route_7_17  vss  10000meg
XMN4_r_7_17  vw_route_7_17  we_route  iwrite_route_7_17  vss  sky130_fd_pr__nfet_01v8  w=0.5  l=0.5
X_rhebb_7_17  iwrite_route_7_17  inp_upper_17  ierr_dig_7  vcm_route  vdd vss  hebbian_mult
XMPRED_r_7_18  i_pred_7  vw_route_7_18  vss  vss  sky130_fd_pr__nfet_01v8  w=4  l=0.35
Cw_route_7_18  vw_route_7_18  vss  200f
R_bleed_7_18  vw_route_7_18  vss  10000meg
XMN4_r_7_18  vw_route_7_18  we_route  iwrite_route_7_18  vss  sky130_fd_pr__nfet_01v8  w=0.5  l=0.5
X_rhebb_7_18  iwrite_route_7_18  inp_upper_18  ierr_dig_7  vcm_route  vdd vss  hebbian_mult
XMPRED_r_7_19  i_pred_7  vw_route_7_19  vss  vss  sky130_fd_pr__nfet_01v8  w=4  l=0.35
Cw_route_7_19  vw_route_7_19  vss  200f
R_bleed_7_19  vw_route_7_19  vss  10000meg
XMN4_r_7_19  vw_route_7_19  we_route  iwrite_route_7_19  vss  sky130_fd_pr__nfet_01v8  w=0.5  l=0.5
X_rhebb_7_19  iwrite_route_7_19  inp_upper_19  ierr_dig_7  vcm_route  vdd vss  hebbian_mult
XMPRED_r_7_20  i_pred_7  vw_route_7_20  vss  vss  sky130_fd_pr__nfet_01v8  w=4  l=0.35
Cw_route_7_20  vw_route_7_20  vss  200f
R_bleed_7_20  vw_route_7_20  vss  10000meg
XMN4_r_7_20  vw_route_7_20  we_route  iwrite_route_7_20  vss  sky130_fd_pr__nfet_01v8  w=0.5  l=0.5
X_rhebb_7_20  iwrite_route_7_20  inp_upper_20  ierr_dig_7  vcm_route  vdd vss  hebbian_mult
XMPRED_r_7_21  i_pred_7  vw_route_7_21  vss  vss  sky130_fd_pr__nfet_01v8  w=4  l=0.35
Cw_route_7_21  vw_route_7_21  vss  200f
R_bleed_7_21  vw_route_7_21  vss  10000meg
XMN4_r_7_21  vw_route_7_21  we_route  iwrite_route_7_21  vss  sky130_fd_pr__nfet_01v8  w=0.5  l=0.5
X_rhebb_7_21  iwrite_route_7_21  inp_upper_21  ierr_dig_7  vcm_route  vdd vss  hebbian_mult
XMPRED_r_7_22  i_pred_7  vw_route_7_22  vss  vss  sky130_fd_pr__nfet_01v8  w=4  l=0.35
Cw_route_7_22  vw_route_7_22  vss  200f
R_bleed_7_22  vw_route_7_22  vss  10000meg
XMN4_r_7_22  vw_route_7_22  we_route  iwrite_route_7_22  vss  sky130_fd_pr__nfet_01v8  w=0.5  l=0.5
X_rhebb_7_22  iwrite_route_7_22  inp_upper_22  ierr_dig_7  vcm_route  vdd vss  hebbian_mult
XMPRED_r_7_23  i_pred_7  vw_route_7_23  vss  vss  sky130_fd_pr__nfet_01v8  w=4  l=0.35
Cw_route_7_23  vw_route_7_23  vss  200f
R_bleed_7_23  vw_route_7_23  vss  10000meg
XMN4_r_7_23  vw_route_7_23  we_route  iwrite_route_7_23  vss  sky130_fd_pr__nfet_01v8  w=0.5  l=0.5
X_rhebb_7_23  iwrite_route_7_23  inp_upper_23  ierr_dig_7  vcm_route  vdd vss  hebbian_mult
XMPRED_r_7_24  i_pred_7  vw_route_7_24  vss  vss  sky130_fd_pr__nfet_01v8  w=4  l=0.35
Cw_route_7_24  vw_route_7_24  vss  200f
R_bleed_7_24  vw_route_7_24  vss  10000meg
XMN4_r_7_24  vw_route_7_24  we_route  iwrite_route_7_24  vss  sky130_fd_pr__nfet_01v8  w=0.5  l=0.5
X_rhebb_7_24  iwrite_route_7_24  inp_upper_24  ierr_dig_7  vcm_route  vdd vss  hebbian_mult
XMPRED_r_7_25  i_pred_7  vw_route_7_25  vss  vss  sky130_fd_pr__nfet_01v8  w=4  l=0.35
Cw_route_7_25  vw_route_7_25  vss  200f
R_bleed_7_25  vw_route_7_25  vss  10000meg
XMN4_r_7_25  vw_route_7_25  we_route  iwrite_route_7_25  vss  sky130_fd_pr__nfet_01v8  w=0.5  l=0.5
X_rhebb_7_25  iwrite_route_7_25  inp_upper_25  ierr_dig_7  vcm_route  vdd vss  hebbian_mult
XMPRED_r_7_26  i_pred_7  vw_route_7_26  vss  vss  sky130_fd_pr__nfet_01v8  w=4  l=0.35
Cw_route_7_26  vw_route_7_26  vss  200f
R_bleed_7_26  vw_route_7_26  vss  10000meg
XMN4_r_7_26  vw_route_7_26  we_route  iwrite_route_7_26  vss  sky130_fd_pr__nfet_01v8  w=0.5  l=0.5
X_rhebb_7_26  iwrite_route_7_26  inp_upper_26  ierr_dig_7  vcm_route  vdd vss  hebbian_mult
XMPRED_r_7_27  i_pred_7  vw_route_7_27  vss  vss  sky130_fd_pr__nfet_01v8  w=4  l=0.35
Cw_route_7_27  vw_route_7_27  vss  200f
R_bleed_7_27  vw_route_7_27  vss  10000meg
XMN4_r_7_27  vw_route_7_27  we_route  iwrite_route_7_27  vss  sky130_fd_pr__nfet_01v8  w=0.5  l=0.5
X_rhebb_7_27  iwrite_route_7_27  inp_upper_27  ierr_dig_7  vcm_route  vdd vss  hebbian_mult
XMPRED_r_7_28  i_pred_7  vw_route_7_28  vss  vss  sky130_fd_pr__nfet_01v8  w=4  l=0.35
Cw_route_7_28  vw_route_7_28  vss  200f
R_bleed_7_28  vw_route_7_28  vss  10000meg
XMN4_r_7_28  vw_route_7_28  we_route  iwrite_route_7_28  vss  sky130_fd_pr__nfet_01v8  w=0.5  l=0.5
X_rhebb_7_28  iwrite_route_7_28  inp_upper_28  ierr_dig_7  vcm_route  vdd vss  hebbian_mult
XMPRED_r_7_29  i_pred_7  vw_route_7_29  vss  vss  sky130_fd_pr__nfet_01v8  w=4  l=0.35
Cw_route_7_29  vw_route_7_29  vss  200f
R_bleed_7_29  vw_route_7_29  vss  10000meg
XMN4_r_7_29  vw_route_7_29  we_route  iwrite_route_7_29  vss  sky130_fd_pr__nfet_01v8  w=0.5  l=0.5
X_rhebb_7_29  iwrite_route_7_29  inp_upper_29  ierr_dig_7  vcm_route  vdd vss  hebbian_mult
XMPRED_r_7_30  i_pred_7  vw_route_7_30  vss  vss  sky130_fd_pr__nfet_01v8  w=4  l=0.35
Cw_route_7_30  vw_route_7_30  vss  200f
R_bleed_7_30  vw_route_7_30  vss  10000meg
XMN4_r_7_30  vw_route_7_30  we_route  iwrite_route_7_30  vss  sky130_fd_pr__nfet_01v8  w=0.5  l=0.5
X_rhebb_7_30  iwrite_route_7_30  inp_upper_30  ierr_dig_7  vcm_route  vdd vss  hebbian_mult
XMPRED_r_7_31  i_pred_7  vw_route_7_31  vss  vss  sky130_fd_pr__nfet_01v8  w=4  l=0.35
Cw_route_7_31  vw_route_7_31  vss  200f
R_bleed_7_31  vw_route_7_31  vss  10000meg
XMN4_r_7_31  vw_route_7_31  we_route  iwrite_route_7_31  vss  sky130_fd_pr__nfet_01v8  w=0.5  l=0.5
X_rhebb_7_31  iwrite_route_7_31  inp_upper_31  ierr_dig_7  vcm_route  vdd vss  hebbian_mult

* ── Destination row 8 ── 32 source connections ──────────────────────────
XMPRED_r_8_0  i_pred_8  vw_route_8_0  vss  vss  sky130_fd_pr__nfet_01v8  w=4  l=0.35
Cw_route_8_0  vw_route_8_0  vss  200f
R_bleed_8_0  vw_route_8_0  vss  10000meg
XMN4_r_8_0  vw_route_8_0  we_route  iwrite_route_8_0  vss  sky130_fd_pr__nfet_01v8  w=0.5  l=0.5
X_rhebb_8_0  iwrite_route_8_0  inp_upper_0  ierr_dig_8  vcm_route  vdd vss  hebbian_mult
XMPRED_r_8_1  i_pred_8  vw_route_8_1  vss  vss  sky130_fd_pr__nfet_01v8  w=4  l=0.35
Cw_route_8_1  vw_route_8_1  vss  200f
R_bleed_8_1  vw_route_8_1  vss  10000meg
XMN4_r_8_1  vw_route_8_1  we_route  iwrite_route_8_1  vss  sky130_fd_pr__nfet_01v8  w=0.5  l=0.5
X_rhebb_8_1  iwrite_route_8_1  inp_upper_1  ierr_dig_8  vcm_route  vdd vss  hebbian_mult
XMPRED_r_8_2  i_pred_8  vw_route_8_2  vss  vss  sky130_fd_pr__nfet_01v8  w=4  l=0.35
Cw_route_8_2  vw_route_8_2  vss  200f
R_bleed_8_2  vw_route_8_2  vss  10000meg
XMN4_r_8_2  vw_route_8_2  we_route  iwrite_route_8_2  vss  sky130_fd_pr__nfet_01v8  w=0.5  l=0.5
X_rhebb_8_2  iwrite_route_8_2  inp_upper_2  ierr_dig_8  vcm_route  vdd vss  hebbian_mult
XMPRED_r_8_3  i_pred_8  vw_route_8_3  vss  vss  sky130_fd_pr__nfet_01v8  w=4  l=0.35
Cw_route_8_3  vw_route_8_3  vss  200f
R_bleed_8_3  vw_route_8_3  vss  10000meg
XMN4_r_8_3  vw_route_8_3  we_route  iwrite_route_8_3  vss  sky130_fd_pr__nfet_01v8  w=0.5  l=0.5
X_rhebb_8_3  iwrite_route_8_3  inp_upper_3  ierr_dig_8  vcm_route  vdd vss  hebbian_mult
XMPRED_r_8_4  i_pred_8  vw_route_8_4  vss  vss  sky130_fd_pr__nfet_01v8  w=4  l=0.35
Cw_route_8_4  vw_route_8_4  vss  200f
R_bleed_8_4  vw_route_8_4  vss  10000meg
XMN4_r_8_4  vw_route_8_4  we_route  iwrite_route_8_4  vss  sky130_fd_pr__nfet_01v8  w=0.5  l=0.5
X_rhebb_8_4  iwrite_route_8_4  inp_upper_4  ierr_dig_8  vcm_route  vdd vss  hebbian_mult
XMPRED_r_8_5  i_pred_8  vw_route_8_5  vss  vss  sky130_fd_pr__nfet_01v8  w=4  l=0.35
Cw_route_8_5  vw_route_8_5  vss  200f
R_bleed_8_5  vw_route_8_5  vss  10000meg
XMN4_r_8_5  vw_route_8_5  we_route  iwrite_route_8_5  vss  sky130_fd_pr__nfet_01v8  w=0.5  l=0.5
X_rhebb_8_5  iwrite_route_8_5  inp_upper_5  ierr_dig_8  vcm_route  vdd vss  hebbian_mult
XMPRED_r_8_6  i_pred_8  vw_route_8_6  vss  vss  sky130_fd_pr__nfet_01v8  w=4  l=0.35
Cw_route_8_6  vw_route_8_6  vss  200f
R_bleed_8_6  vw_route_8_6  vss  10000meg
XMN4_r_8_6  vw_route_8_6  we_route  iwrite_route_8_6  vss  sky130_fd_pr__nfet_01v8  w=0.5  l=0.5
X_rhebb_8_6  iwrite_route_8_6  inp_upper_6  ierr_dig_8  vcm_route  vdd vss  hebbian_mult
XMPRED_r_8_7  i_pred_8  vw_route_8_7  vss  vss  sky130_fd_pr__nfet_01v8  w=4  l=0.35
Cw_route_8_7  vw_route_8_7  vss  200f
R_bleed_8_7  vw_route_8_7  vss  10000meg
XMN4_r_8_7  vw_route_8_7  we_route  iwrite_route_8_7  vss  sky130_fd_pr__nfet_01v8  w=0.5  l=0.5
X_rhebb_8_7  iwrite_route_8_7  inp_upper_7  ierr_dig_8  vcm_route  vdd vss  hebbian_mult
XMPRED_r_8_8  i_pred_8  vw_route_8_8  vss  vss  sky130_fd_pr__nfet_01v8  w=4  l=0.35
Cw_route_8_8  vw_route_8_8  vss  200f
R_bleed_8_8  vw_route_8_8  vss  10000meg
XMN4_r_8_8  vw_route_8_8  we_route  iwrite_route_8_8  vss  sky130_fd_pr__nfet_01v8  w=0.5  l=0.5
X_rhebb_8_8  iwrite_route_8_8  inp_upper_8  ierr_dig_8  vcm_route  vdd vss  hebbian_mult
XMPRED_r_8_9  i_pred_8  vw_route_8_9  vss  vss  sky130_fd_pr__nfet_01v8  w=4  l=0.35
Cw_route_8_9  vw_route_8_9  vss  200f
R_bleed_8_9  vw_route_8_9  vss  10000meg
XMN4_r_8_9  vw_route_8_9  we_route  iwrite_route_8_9  vss  sky130_fd_pr__nfet_01v8  w=0.5  l=0.5
X_rhebb_8_9  iwrite_route_8_9  inp_upper_9  ierr_dig_8  vcm_route  vdd vss  hebbian_mult
XMPRED_r_8_10  i_pred_8  vw_route_8_10  vss  vss  sky130_fd_pr__nfet_01v8  w=4  l=0.35
Cw_route_8_10  vw_route_8_10  vss  200f
R_bleed_8_10  vw_route_8_10  vss  10000meg
XMN4_r_8_10  vw_route_8_10  we_route  iwrite_route_8_10  vss  sky130_fd_pr__nfet_01v8  w=0.5  l=0.5
X_rhebb_8_10  iwrite_route_8_10  inp_upper_10  ierr_dig_8  vcm_route  vdd vss  hebbian_mult
XMPRED_r_8_11  i_pred_8  vw_route_8_11  vss  vss  sky130_fd_pr__nfet_01v8  w=4  l=0.35
Cw_route_8_11  vw_route_8_11  vss  200f
R_bleed_8_11  vw_route_8_11  vss  10000meg
XMN4_r_8_11  vw_route_8_11  we_route  iwrite_route_8_11  vss  sky130_fd_pr__nfet_01v8  w=0.5  l=0.5
X_rhebb_8_11  iwrite_route_8_11  inp_upper_11  ierr_dig_8  vcm_route  vdd vss  hebbian_mult
XMPRED_r_8_12  i_pred_8  vw_route_8_12  vss  vss  sky130_fd_pr__nfet_01v8  w=4  l=0.35
Cw_route_8_12  vw_route_8_12  vss  200f
R_bleed_8_12  vw_route_8_12  vss  10000meg
XMN4_r_8_12  vw_route_8_12  we_route  iwrite_route_8_12  vss  sky130_fd_pr__nfet_01v8  w=0.5  l=0.5
X_rhebb_8_12  iwrite_route_8_12  inp_upper_12  ierr_dig_8  vcm_route  vdd vss  hebbian_mult
XMPRED_r_8_13  i_pred_8  vw_route_8_13  vss  vss  sky130_fd_pr__nfet_01v8  w=4  l=0.35
Cw_route_8_13  vw_route_8_13  vss  200f
R_bleed_8_13  vw_route_8_13  vss  10000meg
XMN4_r_8_13  vw_route_8_13  we_route  iwrite_route_8_13  vss  sky130_fd_pr__nfet_01v8  w=0.5  l=0.5
X_rhebb_8_13  iwrite_route_8_13  inp_upper_13  ierr_dig_8  vcm_route  vdd vss  hebbian_mult
XMPRED_r_8_14  i_pred_8  vw_route_8_14  vss  vss  sky130_fd_pr__nfet_01v8  w=4  l=0.35
Cw_route_8_14  vw_route_8_14  vss  200f
R_bleed_8_14  vw_route_8_14  vss  10000meg
XMN4_r_8_14  vw_route_8_14  we_route  iwrite_route_8_14  vss  sky130_fd_pr__nfet_01v8  w=0.5  l=0.5
X_rhebb_8_14  iwrite_route_8_14  inp_upper_14  ierr_dig_8  vcm_route  vdd vss  hebbian_mult
XMPRED_r_8_15  i_pred_8  vw_route_8_15  vss  vss  sky130_fd_pr__nfet_01v8  w=4  l=0.35
Cw_route_8_15  vw_route_8_15  vss  200f
R_bleed_8_15  vw_route_8_15  vss  10000meg
XMN4_r_8_15  vw_route_8_15  we_route  iwrite_route_8_15  vss  sky130_fd_pr__nfet_01v8  w=0.5  l=0.5
X_rhebb_8_15  iwrite_route_8_15  inp_upper_15  ierr_dig_8  vcm_route  vdd vss  hebbian_mult
XMPRED_r_8_16  i_pred_8  vw_route_8_16  vss  vss  sky130_fd_pr__nfet_01v8  w=4  l=0.35
Cw_route_8_16  vw_route_8_16  vss  200f
R_bleed_8_16  vw_route_8_16  vss  10000meg
XMN4_r_8_16  vw_route_8_16  we_route  iwrite_route_8_16  vss  sky130_fd_pr__nfet_01v8  w=0.5  l=0.5
X_rhebb_8_16  iwrite_route_8_16  inp_upper_16  ierr_dig_8  vcm_route  vdd vss  hebbian_mult
XMPRED_r_8_17  i_pred_8  vw_route_8_17  vss  vss  sky130_fd_pr__nfet_01v8  w=4  l=0.35
Cw_route_8_17  vw_route_8_17  vss  200f
R_bleed_8_17  vw_route_8_17  vss  10000meg
XMN4_r_8_17  vw_route_8_17  we_route  iwrite_route_8_17  vss  sky130_fd_pr__nfet_01v8  w=0.5  l=0.5
X_rhebb_8_17  iwrite_route_8_17  inp_upper_17  ierr_dig_8  vcm_route  vdd vss  hebbian_mult
XMPRED_r_8_18  i_pred_8  vw_route_8_18  vss  vss  sky130_fd_pr__nfet_01v8  w=4  l=0.35
Cw_route_8_18  vw_route_8_18  vss  200f
R_bleed_8_18  vw_route_8_18  vss  10000meg
XMN4_r_8_18  vw_route_8_18  we_route  iwrite_route_8_18  vss  sky130_fd_pr__nfet_01v8  w=0.5  l=0.5
X_rhebb_8_18  iwrite_route_8_18  inp_upper_18  ierr_dig_8  vcm_route  vdd vss  hebbian_mult
XMPRED_r_8_19  i_pred_8  vw_route_8_19  vss  vss  sky130_fd_pr__nfet_01v8  w=4  l=0.35
Cw_route_8_19  vw_route_8_19  vss  200f
R_bleed_8_19  vw_route_8_19  vss  10000meg
XMN4_r_8_19  vw_route_8_19  we_route  iwrite_route_8_19  vss  sky130_fd_pr__nfet_01v8  w=0.5  l=0.5
X_rhebb_8_19  iwrite_route_8_19  inp_upper_19  ierr_dig_8  vcm_route  vdd vss  hebbian_mult
XMPRED_r_8_20  i_pred_8  vw_route_8_20  vss  vss  sky130_fd_pr__nfet_01v8  w=4  l=0.35
Cw_route_8_20  vw_route_8_20  vss  200f
R_bleed_8_20  vw_route_8_20  vss  10000meg
XMN4_r_8_20  vw_route_8_20  we_route  iwrite_route_8_20  vss  sky130_fd_pr__nfet_01v8  w=0.5  l=0.5
X_rhebb_8_20  iwrite_route_8_20  inp_upper_20  ierr_dig_8  vcm_route  vdd vss  hebbian_mult
XMPRED_r_8_21  i_pred_8  vw_route_8_21  vss  vss  sky130_fd_pr__nfet_01v8  w=4  l=0.35
Cw_route_8_21  vw_route_8_21  vss  200f
R_bleed_8_21  vw_route_8_21  vss  10000meg
XMN4_r_8_21  vw_route_8_21  we_route  iwrite_route_8_21  vss  sky130_fd_pr__nfet_01v8  w=0.5  l=0.5
X_rhebb_8_21  iwrite_route_8_21  inp_upper_21  ierr_dig_8  vcm_route  vdd vss  hebbian_mult
XMPRED_r_8_22  i_pred_8  vw_route_8_22  vss  vss  sky130_fd_pr__nfet_01v8  w=4  l=0.35
Cw_route_8_22  vw_route_8_22  vss  200f
R_bleed_8_22  vw_route_8_22  vss  10000meg
XMN4_r_8_22  vw_route_8_22  we_route  iwrite_route_8_22  vss  sky130_fd_pr__nfet_01v8  w=0.5  l=0.5
X_rhebb_8_22  iwrite_route_8_22  inp_upper_22  ierr_dig_8  vcm_route  vdd vss  hebbian_mult
XMPRED_r_8_23  i_pred_8  vw_route_8_23  vss  vss  sky130_fd_pr__nfet_01v8  w=4  l=0.35
Cw_route_8_23  vw_route_8_23  vss  200f
R_bleed_8_23  vw_route_8_23  vss  10000meg
XMN4_r_8_23  vw_route_8_23  we_route  iwrite_route_8_23  vss  sky130_fd_pr__nfet_01v8  w=0.5  l=0.5
X_rhebb_8_23  iwrite_route_8_23  inp_upper_23  ierr_dig_8  vcm_route  vdd vss  hebbian_mult
XMPRED_r_8_24  i_pred_8  vw_route_8_24  vss  vss  sky130_fd_pr__nfet_01v8  w=4  l=0.35
Cw_route_8_24  vw_route_8_24  vss  200f
R_bleed_8_24  vw_route_8_24  vss  10000meg
XMN4_r_8_24  vw_route_8_24  we_route  iwrite_route_8_24  vss  sky130_fd_pr__nfet_01v8  w=0.5  l=0.5
X_rhebb_8_24  iwrite_route_8_24  inp_upper_24  ierr_dig_8  vcm_route  vdd vss  hebbian_mult
XMPRED_r_8_25  i_pred_8  vw_route_8_25  vss  vss  sky130_fd_pr__nfet_01v8  w=4  l=0.35
Cw_route_8_25  vw_route_8_25  vss  200f
R_bleed_8_25  vw_route_8_25  vss  10000meg
XMN4_r_8_25  vw_route_8_25  we_route  iwrite_route_8_25  vss  sky130_fd_pr__nfet_01v8  w=0.5  l=0.5
X_rhebb_8_25  iwrite_route_8_25  inp_upper_25  ierr_dig_8  vcm_route  vdd vss  hebbian_mult
XMPRED_r_8_26  i_pred_8  vw_route_8_26  vss  vss  sky130_fd_pr__nfet_01v8  w=4  l=0.35
Cw_route_8_26  vw_route_8_26  vss  200f
R_bleed_8_26  vw_route_8_26  vss  10000meg
XMN4_r_8_26  vw_route_8_26  we_route  iwrite_route_8_26  vss  sky130_fd_pr__nfet_01v8  w=0.5  l=0.5
X_rhebb_8_26  iwrite_route_8_26  inp_upper_26  ierr_dig_8  vcm_route  vdd vss  hebbian_mult
XMPRED_r_8_27  i_pred_8  vw_route_8_27  vss  vss  sky130_fd_pr__nfet_01v8  w=4  l=0.35
Cw_route_8_27  vw_route_8_27  vss  200f
R_bleed_8_27  vw_route_8_27  vss  10000meg
XMN4_r_8_27  vw_route_8_27  we_route  iwrite_route_8_27  vss  sky130_fd_pr__nfet_01v8  w=0.5  l=0.5
X_rhebb_8_27  iwrite_route_8_27  inp_upper_27  ierr_dig_8  vcm_route  vdd vss  hebbian_mult
XMPRED_r_8_28  i_pred_8  vw_route_8_28  vss  vss  sky130_fd_pr__nfet_01v8  w=4  l=0.35
Cw_route_8_28  vw_route_8_28  vss  200f
R_bleed_8_28  vw_route_8_28  vss  10000meg
XMN4_r_8_28  vw_route_8_28  we_route  iwrite_route_8_28  vss  sky130_fd_pr__nfet_01v8  w=0.5  l=0.5
X_rhebb_8_28  iwrite_route_8_28  inp_upper_28  ierr_dig_8  vcm_route  vdd vss  hebbian_mult
XMPRED_r_8_29  i_pred_8  vw_route_8_29  vss  vss  sky130_fd_pr__nfet_01v8  w=4  l=0.35
Cw_route_8_29  vw_route_8_29  vss  200f
R_bleed_8_29  vw_route_8_29  vss  10000meg
XMN4_r_8_29  vw_route_8_29  we_route  iwrite_route_8_29  vss  sky130_fd_pr__nfet_01v8  w=0.5  l=0.5
X_rhebb_8_29  iwrite_route_8_29  inp_upper_29  ierr_dig_8  vcm_route  vdd vss  hebbian_mult
XMPRED_r_8_30  i_pred_8  vw_route_8_30  vss  vss  sky130_fd_pr__nfet_01v8  w=4  l=0.35
Cw_route_8_30  vw_route_8_30  vss  200f
R_bleed_8_30  vw_route_8_30  vss  10000meg
XMN4_r_8_30  vw_route_8_30  we_route  iwrite_route_8_30  vss  sky130_fd_pr__nfet_01v8  w=0.5  l=0.5
X_rhebb_8_30  iwrite_route_8_30  inp_upper_30  ierr_dig_8  vcm_route  vdd vss  hebbian_mult
XMPRED_r_8_31  i_pred_8  vw_route_8_31  vss  vss  sky130_fd_pr__nfet_01v8  w=4  l=0.35
Cw_route_8_31  vw_route_8_31  vss  200f
R_bleed_8_31  vw_route_8_31  vss  10000meg
XMN4_r_8_31  vw_route_8_31  we_route  iwrite_route_8_31  vss  sky130_fd_pr__nfet_01v8  w=0.5  l=0.5
X_rhebb_8_31  iwrite_route_8_31  inp_upper_31  ierr_dig_8  vcm_route  vdd vss  hebbian_mult

* ── Destination row 9 ── 32 source connections ──────────────────────────
XMPRED_r_9_0  i_pred_9  vw_route_9_0  vss  vss  sky130_fd_pr__nfet_01v8  w=4  l=0.35
Cw_route_9_0  vw_route_9_0  vss  200f
R_bleed_9_0  vw_route_9_0  vss  10000meg
XMN4_r_9_0  vw_route_9_0  we_route  iwrite_route_9_0  vss  sky130_fd_pr__nfet_01v8  w=0.5  l=0.5
X_rhebb_9_0  iwrite_route_9_0  inp_upper_0  ierr_dig_9  vcm_route  vdd vss  hebbian_mult
XMPRED_r_9_1  i_pred_9  vw_route_9_1  vss  vss  sky130_fd_pr__nfet_01v8  w=4  l=0.35
Cw_route_9_1  vw_route_9_1  vss  200f
R_bleed_9_1  vw_route_9_1  vss  10000meg
XMN4_r_9_1  vw_route_9_1  we_route  iwrite_route_9_1  vss  sky130_fd_pr__nfet_01v8  w=0.5  l=0.5
X_rhebb_9_1  iwrite_route_9_1  inp_upper_1  ierr_dig_9  vcm_route  vdd vss  hebbian_mult
XMPRED_r_9_2  i_pred_9  vw_route_9_2  vss  vss  sky130_fd_pr__nfet_01v8  w=4  l=0.35
Cw_route_9_2  vw_route_9_2  vss  200f
R_bleed_9_2  vw_route_9_2  vss  10000meg
XMN4_r_9_2  vw_route_9_2  we_route  iwrite_route_9_2  vss  sky130_fd_pr__nfet_01v8  w=0.5  l=0.5
X_rhebb_9_2  iwrite_route_9_2  inp_upper_2  ierr_dig_9  vcm_route  vdd vss  hebbian_mult
XMPRED_r_9_3  i_pred_9  vw_route_9_3  vss  vss  sky130_fd_pr__nfet_01v8  w=4  l=0.35
Cw_route_9_3  vw_route_9_3  vss  200f
R_bleed_9_3  vw_route_9_3  vss  10000meg
XMN4_r_9_3  vw_route_9_3  we_route  iwrite_route_9_3  vss  sky130_fd_pr__nfet_01v8  w=0.5  l=0.5
X_rhebb_9_3  iwrite_route_9_3  inp_upper_3  ierr_dig_9  vcm_route  vdd vss  hebbian_mult
XMPRED_r_9_4  i_pred_9  vw_route_9_4  vss  vss  sky130_fd_pr__nfet_01v8  w=4  l=0.35
Cw_route_9_4  vw_route_9_4  vss  200f
R_bleed_9_4  vw_route_9_4  vss  10000meg
XMN4_r_9_4  vw_route_9_4  we_route  iwrite_route_9_4  vss  sky130_fd_pr__nfet_01v8  w=0.5  l=0.5
X_rhebb_9_4  iwrite_route_9_4  inp_upper_4  ierr_dig_9  vcm_route  vdd vss  hebbian_mult
XMPRED_r_9_5  i_pred_9  vw_route_9_5  vss  vss  sky130_fd_pr__nfet_01v8  w=4  l=0.35
Cw_route_9_5  vw_route_9_5  vss  200f
R_bleed_9_5  vw_route_9_5  vss  10000meg
XMN4_r_9_5  vw_route_9_5  we_route  iwrite_route_9_5  vss  sky130_fd_pr__nfet_01v8  w=0.5  l=0.5
X_rhebb_9_5  iwrite_route_9_5  inp_upper_5  ierr_dig_9  vcm_route  vdd vss  hebbian_mult
XMPRED_r_9_6  i_pred_9  vw_route_9_6  vss  vss  sky130_fd_pr__nfet_01v8  w=4  l=0.35
Cw_route_9_6  vw_route_9_6  vss  200f
R_bleed_9_6  vw_route_9_6  vss  10000meg
XMN4_r_9_6  vw_route_9_6  we_route  iwrite_route_9_6  vss  sky130_fd_pr__nfet_01v8  w=0.5  l=0.5
X_rhebb_9_6  iwrite_route_9_6  inp_upper_6  ierr_dig_9  vcm_route  vdd vss  hebbian_mult
XMPRED_r_9_7  i_pred_9  vw_route_9_7  vss  vss  sky130_fd_pr__nfet_01v8  w=4  l=0.35
Cw_route_9_7  vw_route_9_7  vss  200f
R_bleed_9_7  vw_route_9_7  vss  10000meg
XMN4_r_9_7  vw_route_9_7  we_route  iwrite_route_9_7  vss  sky130_fd_pr__nfet_01v8  w=0.5  l=0.5
X_rhebb_9_7  iwrite_route_9_7  inp_upper_7  ierr_dig_9  vcm_route  vdd vss  hebbian_mult
XMPRED_r_9_8  i_pred_9  vw_route_9_8  vss  vss  sky130_fd_pr__nfet_01v8  w=4  l=0.35
Cw_route_9_8  vw_route_9_8  vss  200f
R_bleed_9_8  vw_route_9_8  vss  10000meg
XMN4_r_9_8  vw_route_9_8  we_route  iwrite_route_9_8  vss  sky130_fd_pr__nfet_01v8  w=0.5  l=0.5
X_rhebb_9_8  iwrite_route_9_8  inp_upper_8  ierr_dig_9  vcm_route  vdd vss  hebbian_mult
XMPRED_r_9_9  i_pred_9  vw_route_9_9  vss  vss  sky130_fd_pr__nfet_01v8  w=4  l=0.35
Cw_route_9_9  vw_route_9_9  vss  200f
R_bleed_9_9  vw_route_9_9  vss  10000meg
XMN4_r_9_9  vw_route_9_9  we_route  iwrite_route_9_9  vss  sky130_fd_pr__nfet_01v8  w=0.5  l=0.5
X_rhebb_9_9  iwrite_route_9_9  inp_upper_9  ierr_dig_9  vcm_route  vdd vss  hebbian_mult
XMPRED_r_9_10  i_pred_9  vw_route_9_10  vss  vss  sky130_fd_pr__nfet_01v8  w=4  l=0.35
Cw_route_9_10  vw_route_9_10  vss  200f
R_bleed_9_10  vw_route_9_10  vss  10000meg
XMN4_r_9_10  vw_route_9_10  we_route  iwrite_route_9_10  vss  sky130_fd_pr__nfet_01v8  w=0.5  l=0.5
X_rhebb_9_10  iwrite_route_9_10  inp_upper_10  ierr_dig_9  vcm_route  vdd vss  hebbian_mult
XMPRED_r_9_11  i_pred_9  vw_route_9_11  vss  vss  sky130_fd_pr__nfet_01v8  w=4  l=0.35
Cw_route_9_11  vw_route_9_11  vss  200f
R_bleed_9_11  vw_route_9_11  vss  10000meg
XMN4_r_9_11  vw_route_9_11  we_route  iwrite_route_9_11  vss  sky130_fd_pr__nfet_01v8  w=0.5  l=0.5
X_rhebb_9_11  iwrite_route_9_11  inp_upper_11  ierr_dig_9  vcm_route  vdd vss  hebbian_mult
XMPRED_r_9_12  i_pred_9  vw_route_9_12  vss  vss  sky130_fd_pr__nfet_01v8  w=4  l=0.35
Cw_route_9_12  vw_route_9_12  vss  200f
R_bleed_9_12  vw_route_9_12  vss  10000meg
XMN4_r_9_12  vw_route_9_12  we_route  iwrite_route_9_12  vss  sky130_fd_pr__nfet_01v8  w=0.5  l=0.5
X_rhebb_9_12  iwrite_route_9_12  inp_upper_12  ierr_dig_9  vcm_route  vdd vss  hebbian_mult
XMPRED_r_9_13  i_pred_9  vw_route_9_13  vss  vss  sky130_fd_pr__nfet_01v8  w=4  l=0.35
Cw_route_9_13  vw_route_9_13  vss  200f
R_bleed_9_13  vw_route_9_13  vss  10000meg
XMN4_r_9_13  vw_route_9_13  we_route  iwrite_route_9_13  vss  sky130_fd_pr__nfet_01v8  w=0.5  l=0.5
X_rhebb_9_13  iwrite_route_9_13  inp_upper_13  ierr_dig_9  vcm_route  vdd vss  hebbian_mult
XMPRED_r_9_14  i_pred_9  vw_route_9_14  vss  vss  sky130_fd_pr__nfet_01v8  w=4  l=0.35
Cw_route_9_14  vw_route_9_14  vss  200f
R_bleed_9_14  vw_route_9_14  vss  10000meg
XMN4_r_9_14  vw_route_9_14  we_route  iwrite_route_9_14  vss  sky130_fd_pr__nfet_01v8  w=0.5  l=0.5
X_rhebb_9_14  iwrite_route_9_14  inp_upper_14  ierr_dig_9  vcm_route  vdd vss  hebbian_mult
XMPRED_r_9_15  i_pred_9  vw_route_9_15  vss  vss  sky130_fd_pr__nfet_01v8  w=4  l=0.35
Cw_route_9_15  vw_route_9_15  vss  200f
R_bleed_9_15  vw_route_9_15  vss  10000meg
XMN4_r_9_15  vw_route_9_15  we_route  iwrite_route_9_15  vss  sky130_fd_pr__nfet_01v8  w=0.5  l=0.5
X_rhebb_9_15  iwrite_route_9_15  inp_upper_15  ierr_dig_9  vcm_route  vdd vss  hebbian_mult
XMPRED_r_9_16  i_pred_9  vw_route_9_16  vss  vss  sky130_fd_pr__nfet_01v8  w=4  l=0.35
Cw_route_9_16  vw_route_9_16  vss  200f
R_bleed_9_16  vw_route_9_16  vss  10000meg
XMN4_r_9_16  vw_route_9_16  we_route  iwrite_route_9_16  vss  sky130_fd_pr__nfet_01v8  w=0.5  l=0.5
X_rhebb_9_16  iwrite_route_9_16  inp_upper_16  ierr_dig_9  vcm_route  vdd vss  hebbian_mult
XMPRED_r_9_17  i_pred_9  vw_route_9_17  vss  vss  sky130_fd_pr__nfet_01v8  w=4  l=0.35
Cw_route_9_17  vw_route_9_17  vss  200f
R_bleed_9_17  vw_route_9_17  vss  10000meg
XMN4_r_9_17  vw_route_9_17  we_route  iwrite_route_9_17  vss  sky130_fd_pr__nfet_01v8  w=0.5  l=0.5
X_rhebb_9_17  iwrite_route_9_17  inp_upper_17  ierr_dig_9  vcm_route  vdd vss  hebbian_mult
XMPRED_r_9_18  i_pred_9  vw_route_9_18  vss  vss  sky130_fd_pr__nfet_01v8  w=4  l=0.35
Cw_route_9_18  vw_route_9_18  vss  200f
R_bleed_9_18  vw_route_9_18  vss  10000meg
XMN4_r_9_18  vw_route_9_18  we_route  iwrite_route_9_18  vss  sky130_fd_pr__nfet_01v8  w=0.5  l=0.5
X_rhebb_9_18  iwrite_route_9_18  inp_upper_18  ierr_dig_9  vcm_route  vdd vss  hebbian_mult
XMPRED_r_9_19  i_pred_9  vw_route_9_19  vss  vss  sky130_fd_pr__nfet_01v8  w=4  l=0.35
Cw_route_9_19  vw_route_9_19  vss  200f
R_bleed_9_19  vw_route_9_19  vss  10000meg
XMN4_r_9_19  vw_route_9_19  we_route  iwrite_route_9_19  vss  sky130_fd_pr__nfet_01v8  w=0.5  l=0.5
X_rhebb_9_19  iwrite_route_9_19  inp_upper_19  ierr_dig_9  vcm_route  vdd vss  hebbian_mult
XMPRED_r_9_20  i_pred_9  vw_route_9_20  vss  vss  sky130_fd_pr__nfet_01v8  w=4  l=0.35
Cw_route_9_20  vw_route_9_20  vss  200f
R_bleed_9_20  vw_route_9_20  vss  10000meg
XMN4_r_9_20  vw_route_9_20  we_route  iwrite_route_9_20  vss  sky130_fd_pr__nfet_01v8  w=0.5  l=0.5
X_rhebb_9_20  iwrite_route_9_20  inp_upper_20  ierr_dig_9  vcm_route  vdd vss  hebbian_mult
XMPRED_r_9_21  i_pred_9  vw_route_9_21  vss  vss  sky130_fd_pr__nfet_01v8  w=4  l=0.35
Cw_route_9_21  vw_route_9_21  vss  200f
R_bleed_9_21  vw_route_9_21  vss  10000meg
XMN4_r_9_21  vw_route_9_21  we_route  iwrite_route_9_21  vss  sky130_fd_pr__nfet_01v8  w=0.5  l=0.5
X_rhebb_9_21  iwrite_route_9_21  inp_upper_21  ierr_dig_9  vcm_route  vdd vss  hebbian_mult
XMPRED_r_9_22  i_pred_9  vw_route_9_22  vss  vss  sky130_fd_pr__nfet_01v8  w=4  l=0.35
Cw_route_9_22  vw_route_9_22  vss  200f
R_bleed_9_22  vw_route_9_22  vss  10000meg
XMN4_r_9_22  vw_route_9_22  we_route  iwrite_route_9_22  vss  sky130_fd_pr__nfet_01v8  w=0.5  l=0.5
X_rhebb_9_22  iwrite_route_9_22  inp_upper_22  ierr_dig_9  vcm_route  vdd vss  hebbian_mult
XMPRED_r_9_23  i_pred_9  vw_route_9_23  vss  vss  sky130_fd_pr__nfet_01v8  w=4  l=0.35
Cw_route_9_23  vw_route_9_23  vss  200f
R_bleed_9_23  vw_route_9_23  vss  10000meg
XMN4_r_9_23  vw_route_9_23  we_route  iwrite_route_9_23  vss  sky130_fd_pr__nfet_01v8  w=0.5  l=0.5
X_rhebb_9_23  iwrite_route_9_23  inp_upper_23  ierr_dig_9  vcm_route  vdd vss  hebbian_mult
XMPRED_r_9_24  i_pred_9  vw_route_9_24  vss  vss  sky130_fd_pr__nfet_01v8  w=4  l=0.35
Cw_route_9_24  vw_route_9_24  vss  200f
R_bleed_9_24  vw_route_9_24  vss  10000meg
XMN4_r_9_24  vw_route_9_24  we_route  iwrite_route_9_24  vss  sky130_fd_pr__nfet_01v8  w=0.5  l=0.5
X_rhebb_9_24  iwrite_route_9_24  inp_upper_24  ierr_dig_9  vcm_route  vdd vss  hebbian_mult
XMPRED_r_9_25  i_pred_9  vw_route_9_25  vss  vss  sky130_fd_pr__nfet_01v8  w=4  l=0.35
Cw_route_9_25  vw_route_9_25  vss  200f
R_bleed_9_25  vw_route_9_25  vss  10000meg
XMN4_r_9_25  vw_route_9_25  we_route  iwrite_route_9_25  vss  sky130_fd_pr__nfet_01v8  w=0.5  l=0.5
X_rhebb_9_25  iwrite_route_9_25  inp_upper_25  ierr_dig_9  vcm_route  vdd vss  hebbian_mult
XMPRED_r_9_26  i_pred_9  vw_route_9_26  vss  vss  sky130_fd_pr__nfet_01v8  w=4  l=0.35
Cw_route_9_26  vw_route_9_26  vss  200f
R_bleed_9_26  vw_route_9_26  vss  10000meg
XMN4_r_9_26  vw_route_9_26  we_route  iwrite_route_9_26  vss  sky130_fd_pr__nfet_01v8  w=0.5  l=0.5
X_rhebb_9_26  iwrite_route_9_26  inp_upper_26  ierr_dig_9  vcm_route  vdd vss  hebbian_mult
XMPRED_r_9_27  i_pred_9  vw_route_9_27  vss  vss  sky130_fd_pr__nfet_01v8  w=4  l=0.35
Cw_route_9_27  vw_route_9_27  vss  200f
R_bleed_9_27  vw_route_9_27  vss  10000meg
XMN4_r_9_27  vw_route_9_27  we_route  iwrite_route_9_27  vss  sky130_fd_pr__nfet_01v8  w=0.5  l=0.5
X_rhebb_9_27  iwrite_route_9_27  inp_upper_27  ierr_dig_9  vcm_route  vdd vss  hebbian_mult
XMPRED_r_9_28  i_pred_9  vw_route_9_28  vss  vss  sky130_fd_pr__nfet_01v8  w=4  l=0.35
Cw_route_9_28  vw_route_9_28  vss  200f
R_bleed_9_28  vw_route_9_28  vss  10000meg
XMN4_r_9_28  vw_route_9_28  we_route  iwrite_route_9_28  vss  sky130_fd_pr__nfet_01v8  w=0.5  l=0.5
X_rhebb_9_28  iwrite_route_9_28  inp_upper_28  ierr_dig_9  vcm_route  vdd vss  hebbian_mult
XMPRED_r_9_29  i_pred_9  vw_route_9_29  vss  vss  sky130_fd_pr__nfet_01v8  w=4  l=0.35
Cw_route_9_29  vw_route_9_29  vss  200f
R_bleed_9_29  vw_route_9_29  vss  10000meg
XMN4_r_9_29  vw_route_9_29  we_route  iwrite_route_9_29  vss  sky130_fd_pr__nfet_01v8  w=0.5  l=0.5
X_rhebb_9_29  iwrite_route_9_29  inp_upper_29  ierr_dig_9  vcm_route  vdd vss  hebbian_mult
XMPRED_r_9_30  i_pred_9  vw_route_9_30  vss  vss  sky130_fd_pr__nfet_01v8  w=4  l=0.35
Cw_route_9_30  vw_route_9_30  vss  200f
R_bleed_9_30  vw_route_9_30  vss  10000meg
XMN4_r_9_30  vw_route_9_30  we_route  iwrite_route_9_30  vss  sky130_fd_pr__nfet_01v8  w=0.5  l=0.5
X_rhebb_9_30  iwrite_route_9_30  inp_upper_30  ierr_dig_9  vcm_route  vdd vss  hebbian_mult
XMPRED_r_9_31  i_pred_9  vw_route_9_31  vss  vss  sky130_fd_pr__nfet_01v8  w=4  l=0.35
Cw_route_9_31  vw_route_9_31  vss  200f
R_bleed_9_31  vw_route_9_31  vss  10000meg
XMN4_r_9_31  vw_route_9_31  we_route  iwrite_route_9_31  vss  sky130_fd_pr__nfet_01v8  w=0.5  l=0.5
X_rhebb_9_31  iwrite_route_9_31  inp_upper_31  ierr_dig_9  vcm_route  vdd vss  hebbian_mult

* ── Destination row 10 ── 32 source connections ──────────────────────────
XMPRED_r_10_0  i_pred_10  vw_route_10_0  vss  vss  sky130_fd_pr__nfet_01v8  w=4  l=0.35
Cw_route_10_0  vw_route_10_0  vss  200f
R_bleed_10_0  vw_route_10_0  vss  10000meg
XMN4_r_10_0  vw_route_10_0  we_route  iwrite_route_10_0  vss  sky130_fd_pr__nfet_01v8  w=0.5  l=0.5
X_rhebb_10_0  iwrite_route_10_0  inp_upper_0  ierr_dig_10  vcm_route  vdd vss  hebbian_mult
XMPRED_r_10_1  i_pred_10  vw_route_10_1  vss  vss  sky130_fd_pr__nfet_01v8  w=4  l=0.35
Cw_route_10_1  vw_route_10_1  vss  200f
R_bleed_10_1  vw_route_10_1  vss  10000meg
XMN4_r_10_1  vw_route_10_1  we_route  iwrite_route_10_1  vss  sky130_fd_pr__nfet_01v8  w=0.5  l=0.5
X_rhebb_10_1  iwrite_route_10_1  inp_upper_1  ierr_dig_10  vcm_route  vdd vss  hebbian_mult
XMPRED_r_10_2  i_pred_10  vw_route_10_2  vss  vss  sky130_fd_pr__nfet_01v8  w=4  l=0.35
Cw_route_10_2  vw_route_10_2  vss  200f
R_bleed_10_2  vw_route_10_2  vss  10000meg
XMN4_r_10_2  vw_route_10_2  we_route  iwrite_route_10_2  vss  sky130_fd_pr__nfet_01v8  w=0.5  l=0.5
X_rhebb_10_2  iwrite_route_10_2  inp_upper_2  ierr_dig_10  vcm_route  vdd vss  hebbian_mult
XMPRED_r_10_3  i_pred_10  vw_route_10_3  vss  vss  sky130_fd_pr__nfet_01v8  w=4  l=0.35
Cw_route_10_3  vw_route_10_3  vss  200f
R_bleed_10_3  vw_route_10_3  vss  10000meg
XMN4_r_10_3  vw_route_10_3  we_route  iwrite_route_10_3  vss  sky130_fd_pr__nfet_01v8  w=0.5  l=0.5
X_rhebb_10_3  iwrite_route_10_3  inp_upper_3  ierr_dig_10  vcm_route  vdd vss  hebbian_mult
XMPRED_r_10_4  i_pred_10  vw_route_10_4  vss  vss  sky130_fd_pr__nfet_01v8  w=4  l=0.35
Cw_route_10_4  vw_route_10_4  vss  200f
R_bleed_10_4  vw_route_10_4  vss  10000meg
XMN4_r_10_4  vw_route_10_4  we_route  iwrite_route_10_4  vss  sky130_fd_pr__nfet_01v8  w=0.5  l=0.5
X_rhebb_10_4  iwrite_route_10_4  inp_upper_4  ierr_dig_10  vcm_route  vdd vss  hebbian_mult
XMPRED_r_10_5  i_pred_10  vw_route_10_5  vss  vss  sky130_fd_pr__nfet_01v8  w=4  l=0.35
Cw_route_10_5  vw_route_10_5  vss  200f
R_bleed_10_5  vw_route_10_5  vss  10000meg
XMN4_r_10_5  vw_route_10_5  we_route  iwrite_route_10_5  vss  sky130_fd_pr__nfet_01v8  w=0.5  l=0.5
X_rhebb_10_5  iwrite_route_10_5  inp_upper_5  ierr_dig_10  vcm_route  vdd vss  hebbian_mult
XMPRED_r_10_6  i_pred_10  vw_route_10_6  vss  vss  sky130_fd_pr__nfet_01v8  w=4  l=0.35
Cw_route_10_6  vw_route_10_6  vss  200f
R_bleed_10_6  vw_route_10_6  vss  10000meg
XMN4_r_10_6  vw_route_10_6  we_route  iwrite_route_10_6  vss  sky130_fd_pr__nfet_01v8  w=0.5  l=0.5
X_rhebb_10_6  iwrite_route_10_6  inp_upper_6  ierr_dig_10  vcm_route  vdd vss  hebbian_mult
XMPRED_r_10_7  i_pred_10  vw_route_10_7  vss  vss  sky130_fd_pr__nfet_01v8  w=4  l=0.35
Cw_route_10_7  vw_route_10_7  vss  200f
R_bleed_10_7  vw_route_10_7  vss  10000meg
XMN4_r_10_7  vw_route_10_7  we_route  iwrite_route_10_7  vss  sky130_fd_pr__nfet_01v8  w=0.5  l=0.5
X_rhebb_10_7  iwrite_route_10_7  inp_upper_7  ierr_dig_10  vcm_route  vdd vss  hebbian_mult
XMPRED_r_10_8  i_pred_10  vw_route_10_8  vss  vss  sky130_fd_pr__nfet_01v8  w=4  l=0.35
Cw_route_10_8  vw_route_10_8  vss  200f
R_bleed_10_8  vw_route_10_8  vss  10000meg
XMN4_r_10_8  vw_route_10_8  we_route  iwrite_route_10_8  vss  sky130_fd_pr__nfet_01v8  w=0.5  l=0.5
X_rhebb_10_8  iwrite_route_10_8  inp_upper_8  ierr_dig_10  vcm_route  vdd vss  hebbian_mult
XMPRED_r_10_9  i_pred_10  vw_route_10_9  vss  vss  sky130_fd_pr__nfet_01v8  w=4  l=0.35
Cw_route_10_9  vw_route_10_9  vss  200f
R_bleed_10_9  vw_route_10_9  vss  10000meg
XMN4_r_10_9  vw_route_10_9  we_route  iwrite_route_10_9  vss  sky130_fd_pr__nfet_01v8  w=0.5  l=0.5
X_rhebb_10_9  iwrite_route_10_9  inp_upper_9  ierr_dig_10  vcm_route  vdd vss  hebbian_mult
XMPRED_r_10_10  i_pred_10  vw_route_10_10  vss  vss  sky130_fd_pr__nfet_01v8  w=4  l=0.35
Cw_route_10_10  vw_route_10_10  vss  200f
R_bleed_10_10  vw_route_10_10  vss  10000meg
XMN4_r_10_10  vw_route_10_10  we_route  iwrite_route_10_10  vss  sky130_fd_pr__nfet_01v8  w=0.5  l=0.5
X_rhebb_10_10  iwrite_route_10_10  inp_upper_10  ierr_dig_10  vcm_route  vdd vss  hebbian_mult
XMPRED_r_10_11  i_pred_10  vw_route_10_11  vss  vss  sky130_fd_pr__nfet_01v8  w=4  l=0.35
Cw_route_10_11  vw_route_10_11  vss  200f
R_bleed_10_11  vw_route_10_11  vss  10000meg
XMN4_r_10_11  vw_route_10_11  we_route  iwrite_route_10_11  vss  sky130_fd_pr__nfet_01v8  w=0.5  l=0.5
X_rhebb_10_11  iwrite_route_10_11  inp_upper_11  ierr_dig_10  vcm_route  vdd vss  hebbian_mult
XMPRED_r_10_12  i_pred_10  vw_route_10_12  vss  vss  sky130_fd_pr__nfet_01v8  w=4  l=0.35
Cw_route_10_12  vw_route_10_12  vss  200f
R_bleed_10_12  vw_route_10_12  vss  10000meg
XMN4_r_10_12  vw_route_10_12  we_route  iwrite_route_10_12  vss  sky130_fd_pr__nfet_01v8  w=0.5  l=0.5
X_rhebb_10_12  iwrite_route_10_12  inp_upper_12  ierr_dig_10  vcm_route  vdd vss  hebbian_mult
XMPRED_r_10_13  i_pred_10  vw_route_10_13  vss  vss  sky130_fd_pr__nfet_01v8  w=4  l=0.35
Cw_route_10_13  vw_route_10_13  vss  200f
R_bleed_10_13  vw_route_10_13  vss  10000meg
XMN4_r_10_13  vw_route_10_13  we_route  iwrite_route_10_13  vss  sky130_fd_pr__nfet_01v8  w=0.5  l=0.5
X_rhebb_10_13  iwrite_route_10_13  inp_upper_13  ierr_dig_10  vcm_route  vdd vss  hebbian_mult
XMPRED_r_10_14  i_pred_10  vw_route_10_14  vss  vss  sky130_fd_pr__nfet_01v8  w=4  l=0.35
Cw_route_10_14  vw_route_10_14  vss  200f
R_bleed_10_14  vw_route_10_14  vss  10000meg
XMN4_r_10_14  vw_route_10_14  we_route  iwrite_route_10_14  vss  sky130_fd_pr__nfet_01v8  w=0.5  l=0.5
X_rhebb_10_14  iwrite_route_10_14  inp_upper_14  ierr_dig_10  vcm_route  vdd vss  hebbian_mult
XMPRED_r_10_15  i_pred_10  vw_route_10_15  vss  vss  sky130_fd_pr__nfet_01v8  w=4  l=0.35
Cw_route_10_15  vw_route_10_15  vss  200f
R_bleed_10_15  vw_route_10_15  vss  10000meg
XMN4_r_10_15  vw_route_10_15  we_route  iwrite_route_10_15  vss  sky130_fd_pr__nfet_01v8  w=0.5  l=0.5
X_rhebb_10_15  iwrite_route_10_15  inp_upper_15  ierr_dig_10  vcm_route  vdd vss  hebbian_mult
XMPRED_r_10_16  i_pred_10  vw_route_10_16  vss  vss  sky130_fd_pr__nfet_01v8  w=4  l=0.35
Cw_route_10_16  vw_route_10_16  vss  200f
R_bleed_10_16  vw_route_10_16  vss  10000meg
XMN4_r_10_16  vw_route_10_16  we_route  iwrite_route_10_16  vss  sky130_fd_pr__nfet_01v8  w=0.5  l=0.5
X_rhebb_10_16  iwrite_route_10_16  inp_upper_16  ierr_dig_10  vcm_route  vdd vss  hebbian_mult
XMPRED_r_10_17  i_pred_10  vw_route_10_17  vss  vss  sky130_fd_pr__nfet_01v8  w=4  l=0.35
Cw_route_10_17  vw_route_10_17  vss  200f
R_bleed_10_17  vw_route_10_17  vss  10000meg
XMN4_r_10_17  vw_route_10_17  we_route  iwrite_route_10_17  vss  sky130_fd_pr__nfet_01v8  w=0.5  l=0.5
X_rhebb_10_17  iwrite_route_10_17  inp_upper_17  ierr_dig_10  vcm_route  vdd vss  hebbian_mult
XMPRED_r_10_18  i_pred_10  vw_route_10_18  vss  vss  sky130_fd_pr__nfet_01v8  w=4  l=0.35
Cw_route_10_18  vw_route_10_18  vss  200f
R_bleed_10_18  vw_route_10_18  vss  10000meg
XMN4_r_10_18  vw_route_10_18  we_route  iwrite_route_10_18  vss  sky130_fd_pr__nfet_01v8  w=0.5  l=0.5
X_rhebb_10_18  iwrite_route_10_18  inp_upper_18  ierr_dig_10  vcm_route  vdd vss  hebbian_mult
XMPRED_r_10_19  i_pred_10  vw_route_10_19  vss  vss  sky130_fd_pr__nfet_01v8  w=4  l=0.35
Cw_route_10_19  vw_route_10_19  vss  200f
R_bleed_10_19  vw_route_10_19  vss  10000meg
XMN4_r_10_19  vw_route_10_19  we_route  iwrite_route_10_19  vss  sky130_fd_pr__nfet_01v8  w=0.5  l=0.5
X_rhebb_10_19  iwrite_route_10_19  inp_upper_19  ierr_dig_10  vcm_route  vdd vss  hebbian_mult
XMPRED_r_10_20  i_pred_10  vw_route_10_20  vss  vss  sky130_fd_pr__nfet_01v8  w=4  l=0.35
Cw_route_10_20  vw_route_10_20  vss  200f
R_bleed_10_20  vw_route_10_20  vss  10000meg
XMN4_r_10_20  vw_route_10_20  we_route  iwrite_route_10_20  vss  sky130_fd_pr__nfet_01v8  w=0.5  l=0.5
X_rhebb_10_20  iwrite_route_10_20  inp_upper_20  ierr_dig_10  vcm_route  vdd vss  hebbian_mult
XMPRED_r_10_21  i_pred_10  vw_route_10_21  vss  vss  sky130_fd_pr__nfet_01v8  w=4  l=0.35
Cw_route_10_21  vw_route_10_21  vss  200f
R_bleed_10_21  vw_route_10_21  vss  10000meg
XMN4_r_10_21  vw_route_10_21  we_route  iwrite_route_10_21  vss  sky130_fd_pr__nfet_01v8  w=0.5  l=0.5
X_rhebb_10_21  iwrite_route_10_21  inp_upper_21  ierr_dig_10  vcm_route  vdd vss  hebbian_mult
XMPRED_r_10_22  i_pred_10  vw_route_10_22  vss  vss  sky130_fd_pr__nfet_01v8  w=4  l=0.35
Cw_route_10_22  vw_route_10_22  vss  200f
R_bleed_10_22  vw_route_10_22  vss  10000meg
XMN4_r_10_22  vw_route_10_22  we_route  iwrite_route_10_22  vss  sky130_fd_pr__nfet_01v8  w=0.5  l=0.5
X_rhebb_10_22  iwrite_route_10_22  inp_upper_22  ierr_dig_10  vcm_route  vdd vss  hebbian_mult
XMPRED_r_10_23  i_pred_10  vw_route_10_23  vss  vss  sky130_fd_pr__nfet_01v8  w=4  l=0.35
Cw_route_10_23  vw_route_10_23  vss  200f
R_bleed_10_23  vw_route_10_23  vss  10000meg
XMN4_r_10_23  vw_route_10_23  we_route  iwrite_route_10_23  vss  sky130_fd_pr__nfet_01v8  w=0.5  l=0.5
X_rhebb_10_23  iwrite_route_10_23  inp_upper_23  ierr_dig_10  vcm_route  vdd vss  hebbian_mult
XMPRED_r_10_24  i_pred_10  vw_route_10_24  vss  vss  sky130_fd_pr__nfet_01v8  w=4  l=0.35
Cw_route_10_24  vw_route_10_24  vss  200f
R_bleed_10_24  vw_route_10_24  vss  10000meg
XMN4_r_10_24  vw_route_10_24  we_route  iwrite_route_10_24  vss  sky130_fd_pr__nfet_01v8  w=0.5  l=0.5
X_rhebb_10_24  iwrite_route_10_24  inp_upper_24  ierr_dig_10  vcm_route  vdd vss  hebbian_mult
XMPRED_r_10_25  i_pred_10  vw_route_10_25  vss  vss  sky130_fd_pr__nfet_01v8  w=4  l=0.35
Cw_route_10_25  vw_route_10_25  vss  200f
R_bleed_10_25  vw_route_10_25  vss  10000meg
XMN4_r_10_25  vw_route_10_25  we_route  iwrite_route_10_25  vss  sky130_fd_pr__nfet_01v8  w=0.5  l=0.5
X_rhebb_10_25  iwrite_route_10_25  inp_upper_25  ierr_dig_10  vcm_route  vdd vss  hebbian_mult
XMPRED_r_10_26  i_pred_10  vw_route_10_26  vss  vss  sky130_fd_pr__nfet_01v8  w=4  l=0.35
Cw_route_10_26  vw_route_10_26  vss  200f
R_bleed_10_26  vw_route_10_26  vss  10000meg
XMN4_r_10_26  vw_route_10_26  we_route  iwrite_route_10_26  vss  sky130_fd_pr__nfet_01v8  w=0.5  l=0.5
X_rhebb_10_26  iwrite_route_10_26  inp_upper_26  ierr_dig_10  vcm_route  vdd vss  hebbian_mult
XMPRED_r_10_27  i_pred_10  vw_route_10_27  vss  vss  sky130_fd_pr__nfet_01v8  w=4  l=0.35
Cw_route_10_27  vw_route_10_27  vss  200f
R_bleed_10_27  vw_route_10_27  vss  10000meg
XMN4_r_10_27  vw_route_10_27  we_route  iwrite_route_10_27  vss  sky130_fd_pr__nfet_01v8  w=0.5  l=0.5
X_rhebb_10_27  iwrite_route_10_27  inp_upper_27  ierr_dig_10  vcm_route  vdd vss  hebbian_mult
XMPRED_r_10_28  i_pred_10  vw_route_10_28  vss  vss  sky130_fd_pr__nfet_01v8  w=4  l=0.35
Cw_route_10_28  vw_route_10_28  vss  200f
R_bleed_10_28  vw_route_10_28  vss  10000meg
XMN4_r_10_28  vw_route_10_28  we_route  iwrite_route_10_28  vss  sky130_fd_pr__nfet_01v8  w=0.5  l=0.5
X_rhebb_10_28  iwrite_route_10_28  inp_upper_28  ierr_dig_10  vcm_route  vdd vss  hebbian_mult
XMPRED_r_10_29  i_pred_10  vw_route_10_29  vss  vss  sky130_fd_pr__nfet_01v8  w=4  l=0.35
Cw_route_10_29  vw_route_10_29  vss  200f
R_bleed_10_29  vw_route_10_29  vss  10000meg
XMN4_r_10_29  vw_route_10_29  we_route  iwrite_route_10_29  vss  sky130_fd_pr__nfet_01v8  w=0.5  l=0.5
X_rhebb_10_29  iwrite_route_10_29  inp_upper_29  ierr_dig_10  vcm_route  vdd vss  hebbian_mult
XMPRED_r_10_30  i_pred_10  vw_route_10_30  vss  vss  sky130_fd_pr__nfet_01v8  w=4  l=0.35
Cw_route_10_30  vw_route_10_30  vss  200f
R_bleed_10_30  vw_route_10_30  vss  10000meg
XMN4_r_10_30  vw_route_10_30  we_route  iwrite_route_10_30  vss  sky130_fd_pr__nfet_01v8  w=0.5  l=0.5
X_rhebb_10_30  iwrite_route_10_30  inp_upper_30  ierr_dig_10  vcm_route  vdd vss  hebbian_mult
XMPRED_r_10_31  i_pred_10  vw_route_10_31  vss  vss  sky130_fd_pr__nfet_01v8  w=4  l=0.35
Cw_route_10_31  vw_route_10_31  vss  200f
R_bleed_10_31  vw_route_10_31  vss  10000meg
XMN4_r_10_31  vw_route_10_31  we_route  iwrite_route_10_31  vss  sky130_fd_pr__nfet_01v8  w=0.5  l=0.5
X_rhebb_10_31  iwrite_route_10_31  inp_upper_31  ierr_dig_10  vcm_route  vdd vss  hebbian_mult

* ── Destination row 11 ── 32 source connections ──────────────────────────
XMPRED_r_11_0  i_pred_11  vw_route_11_0  vss  vss  sky130_fd_pr__nfet_01v8  w=4  l=0.35
Cw_route_11_0  vw_route_11_0  vss  200f
R_bleed_11_0  vw_route_11_0  vss  10000meg
XMN4_r_11_0  vw_route_11_0  we_route  iwrite_route_11_0  vss  sky130_fd_pr__nfet_01v8  w=0.5  l=0.5
X_rhebb_11_0  iwrite_route_11_0  inp_upper_0  ierr_dig_11  vcm_route  vdd vss  hebbian_mult
XMPRED_r_11_1  i_pred_11  vw_route_11_1  vss  vss  sky130_fd_pr__nfet_01v8  w=4  l=0.35
Cw_route_11_1  vw_route_11_1  vss  200f
R_bleed_11_1  vw_route_11_1  vss  10000meg
XMN4_r_11_1  vw_route_11_1  we_route  iwrite_route_11_1  vss  sky130_fd_pr__nfet_01v8  w=0.5  l=0.5
X_rhebb_11_1  iwrite_route_11_1  inp_upper_1  ierr_dig_11  vcm_route  vdd vss  hebbian_mult
XMPRED_r_11_2  i_pred_11  vw_route_11_2  vss  vss  sky130_fd_pr__nfet_01v8  w=4  l=0.35
Cw_route_11_2  vw_route_11_2  vss  200f
R_bleed_11_2  vw_route_11_2  vss  10000meg
XMN4_r_11_2  vw_route_11_2  we_route  iwrite_route_11_2  vss  sky130_fd_pr__nfet_01v8  w=0.5  l=0.5
X_rhebb_11_2  iwrite_route_11_2  inp_upper_2  ierr_dig_11  vcm_route  vdd vss  hebbian_mult
XMPRED_r_11_3  i_pred_11  vw_route_11_3  vss  vss  sky130_fd_pr__nfet_01v8  w=4  l=0.35
Cw_route_11_3  vw_route_11_3  vss  200f
R_bleed_11_3  vw_route_11_3  vss  10000meg
XMN4_r_11_3  vw_route_11_3  we_route  iwrite_route_11_3  vss  sky130_fd_pr__nfet_01v8  w=0.5  l=0.5
X_rhebb_11_3  iwrite_route_11_3  inp_upper_3  ierr_dig_11  vcm_route  vdd vss  hebbian_mult
XMPRED_r_11_4  i_pred_11  vw_route_11_4  vss  vss  sky130_fd_pr__nfet_01v8  w=4  l=0.35
Cw_route_11_4  vw_route_11_4  vss  200f
R_bleed_11_4  vw_route_11_4  vss  10000meg
XMN4_r_11_4  vw_route_11_4  we_route  iwrite_route_11_4  vss  sky130_fd_pr__nfet_01v8  w=0.5  l=0.5
X_rhebb_11_4  iwrite_route_11_4  inp_upper_4  ierr_dig_11  vcm_route  vdd vss  hebbian_mult
XMPRED_r_11_5  i_pred_11  vw_route_11_5  vss  vss  sky130_fd_pr__nfet_01v8  w=4  l=0.35
Cw_route_11_5  vw_route_11_5  vss  200f
R_bleed_11_5  vw_route_11_5  vss  10000meg
XMN4_r_11_5  vw_route_11_5  we_route  iwrite_route_11_5  vss  sky130_fd_pr__nfet_01v8  w=0.5  l=0.5
X_rhebb_11_5  iwrite_route_11_5  inp_upper_5  ierr_dig_11  vcm_route  vdd vss  hebbian_mult
XMPRED_r_11_6  i_pred_11  vw_route_11_6  vss  vss  sky130_fd_pr__nfet_01v8  w=4  l=0.35
Cw_route_11_6  vw_route_11_6  vss  200f
R_bleed_11_6  vw_route_11_6  vss  10000meg
XMN4_r_11_6  vw_route_11_6  we_route  iwrite_route_11_6  vss  sky130_fd_pr__nfet_01v8  w=0.5  l=0.5
X_rhebb_11_6  iwrite_route_11_6  inp_upper_6  ierr_dig_11  vcm_route  vdd vss  hebbian_mult
XMPRED_r_11_7  i_pred_11  vw_route_11_7  vss  vss  sky130_fd_pr__nfet_01v8  w=4  l=0.35
Cw_route_11_7  vw_route_11_7  vss  200f
R_bleed_11_7  vw_route_11_7  vss  10000meg
XMN4_r_11_7  vw_route_11_7  we_route  iwrite_route_11_7  vss  sky130_fd_pr__nfet_01v8  w=0.5  l=0.5
X_rhebb_11_7  iwrite_route_11_7  inp_upper_7  ierr_dig_11  vcm_route  vdd vss  hebbian_mult
XMPRED_r_11_8  i_pred_11  vw_route_11_8  vss  vss  sky130_fd_pr__nfet_01v8  w=4  l=0.35
Cw_route_11_8  vw_route_11_8  vss  200f
R_bleed_11_8  vw_route_11_8  vss  10000meg
XMN4_r_11_8  vw_route_11_8  we_route  iwrite_route_11_8  vss  sky130_fd_pr__nfet_01v8  w=0.5  l=0.5
X_rhebb_11_8  iwrite_route_11_8  inp_upper_8  ierr_dig_11  vcm_route  vdd vss  hebbian_mult
XMPRED_r_11_9  i_pred_11  vw_route_11_9  vss  vss  sky130_fd_pr__nfet_01v8  w=4  l=0.35
Cw_route_11_9  vw_route_11_9  vss  200f
R_bleed_11_9  vw_route_11_9  vss  10000meg
XMN4_r_11_9  vw_route_11_9  we_route  iwrite_route_11_9  vss  sky130_fd_pr__nfet_01v8  w=0.5  l=0.5
X_rhebb_11_9  iwrite_route_11_9  inp_upper_9  ierr_dig_11  vcm_route  vdd vss  hebbian_mult
XMPRED_r_11_10  i_pred_11  vw_route_11_10  vss  vss  sky130_fd_pr__nfet_01v8  w=4  l=0.35
Cw_route_11_10  vw_route_11_10  vss  200f
R_bleed_11_10  vw_route_11_10  vss  10000meg
XMN4_r_11_10  vw_route_11_10  we_route  iwrite_route_11_10  vss  sky130_fd_pr__nfet_01v8  w=0.5  l=0.5
X_rhebb_11_10  iwrite_route_11_10  inp_upper_10  ierr_dig_11  vcm_route  vdd vss  hebbian_mult
XMPRED_r_11_11  i_pred_11  vw_route_11_11  vss  vss  sky130_fd_pr__nfet_01v8  w=4  l=0.35
Cw_route_11_11  vw_route_11_11  vss  200f
R_bleed_11_11  vw_route_11_11  vss  10000meg
XMN4_r_11_11  vw_route_11_11  we_route  iwrite_route_11_11  vss  sky130_fd_pr__nfet_01v8  w=0.5  l=0.5
X_rhebb_11_11  iwrite_route_11_11  inp_upper_11  ierr_dig_11  vcm_route  vdd vss  hebbian_mult
XMPRED_r_11_12  i_pred_11  vw_route_11_12  vss  vss  sky130_fd_pr__nfet_01v8  w=4  l=0.35
Cw_route_11_12  vw_route_11_12  vss  200f
R_bleed_11_12  vw_route_11_12  vss  10000meg
XMN4_r_11_12  vw_route_11_12  we_route  iwrite_route_11_12  vss  sky130_fd_pr__nfet_01v8  w=0.5  l=0.5
X_rhebb_11_12  iwrite_route_11_12  inp_upper_12  ierr_dig_11  vcm_route  vdd vss  hebbian_mult
XMPRED_r_11_13  i_pred_11  vw_route_11_13  vss  vss  sky130_fd_pr__nfet_01v8  w=4  l=0.35
Cw_route_11_13  vw_route_11_13  vss  200f
R_bleed_11_13  vw_route_11_13  vss  10000meg
XMN4_r_11_13  vw_route_11_13  we_route  iwrite_route_11_13  vss  sky130_fd_pr__nfet_01v8  w=0.5  l=0.5
X_rhebb_11_13  iwrite_route_11_13  inp_upper_13  ierr_dig_11  vcm_route  vdd vss  hebbian_mult
XMPRED_r_11_14  i_pred_11  vw_route_11_14  vss  vss  sky130_fd_pr__nfet_01v8  w=4  l=0.35
Cw_route_11_14  vw_route_11_14  vss  200f
R_bleed_11_14  vw_route_11_14  vss  10000meg
XMN4_r_11_14  vw_route_11_14  we_route  iwrite_route_11_14  vss  sky130_fd_pr__nfet_01v8  w=0.5  l=0.5
X_rhebb_11_14  iwrite_route_11_14  inp_upper_14  ierr_dig_11  vcm_route  vdd vss  hebbian_mult
XMPRED_r_11_15  i_pred_11  vw_route_11_15  vss  vss  sky130_fd_pr__nfet_01v8  w=4  l=0.35
Cw_route_11_15  vw_route_11_15  vss  200f
R_bleed_11_15  vw_route_11_15  vss  10000meg
XMN4_r_11_15  vw_route_11_15  we_route  iwrite_route_11_15  vss  sky130_fd_pr__nfet_01v8  w=0.5  l=0.5
X_rhebb_11_15  iwrite_route_11_15  inp_upper_15  ierr_dig_11  vcm_route  vdd vss  hebbian_mult
XMPRED_r_11_16  i_pred_11  vw_route_11_16  vss  vss  sky130_fd_pr__nfet_01v8  w=4  l=0.35
Cw_route_11_16  vw_route_11_16  vss  200f
R_bleed_11_16  vw_route_11_16  vss  10000meg
XMN4_r_11_16  vw_route_11_16  we_route  iwrite_route_11_16  vss  sky130_fd_pr__nfet_01v8  w=0.5  l=0.5
X_rhebb_11_16  iwrite_route_11_16  inp_upper_16  ierr_dig_11  vcm_route  vdd vss  hebbian_mult
XMPRED_r_11_17  i_pred_11  vw_route_11_17  vss  vss  sky130_fd_pr__nfet_01v8  w=4  l=0.35
Cw_route_11_17  vw_route_11_17  vss  200f
R_bleed_11_17  vw_route_11_17  vss  10000meg
XMN4_r_11_17  vw_route_11_17  we_route  iwrite_route_11_17  vss  sky130_fd_pr__nfet_01v8  w=0.5  l=0.5
X_rhebb_11_17  iwrite_route_11_17  inp_upper_17  ierr_dig_11  vcm_route  vdd vss  hebbian_mult
XMPRED_r_11_18  i_pred_11  vw_route_11_18  vss  vss  sky130_fd_pr__nfet_01v8  w=4  l=0.35
Cw_route_11_18  vw_route_11_18  vss  200f
R_bleed_11_18  vw_route_11_18  vss  10000meg
XMN4_r_11_18  vw_route_11_18  we_route  iwrite_route_11_18  vss  sky130_fd_pr__nfet_01v8  w=0.5  l=0.5
X_rhebb_11_18  iwrite_route_11_18  inp_upper_18  ierr_dig_11  vcm_route  vdd vss  hebbian_mult
XMPRED_r_11_19  i_pred_11  vw_route_11_19  vss  vss  sky130_fd_pr__nfet_01v8  w=4  l=0.35
Cw_route_11_19  vw_route_11_19  vss  200f
R_bleed_11_19  vw_route_11_19  vss  10000meg
XMN4_r_11_19  vw_route_11_19  we_route  iwrite_route_11_19  vss  sky130_fd_pr__nfet_01v8  w=0.5  l=0.5
X_rhebb_11_19  iwrite_route_11_19  inp_upper_19  ierr_dig_11  vcm_route  vdd vss  hebbian_mult
XMPRED_r_11_20  i_pred_11  vw_route_11_20  vss  vss  sky130_fd_pr__nfet_01v8  w=4  l=0.35
Cw_route_11_20  vw_route_11_20  vss  200f
R_bleed_11_20  vw_route_11_20  vss  10000meg
XMN4_r_11_20  vw_route_11_20  we_route  iwrite_route_11_20  vss  sky130_fd_pr__nfet_01v8  w=0.5  l=0.5
X_rhebb_11_20  iwrite_route_11_20  inp_upper_20  ierr_dig_11  vcm_route  vdd vss  hebbian_mult
XMPRED_r_11_21  i_pred_11  vw_route_11_21  vss  vss  sky130_fd_pr__nfet_01v8  w=4  l=0.35
Cw_route_11_21  vw_route_11_21  vss  200f
R_bleed_11_21  vw_route_11_21  vss  10000meg
XMN4_r_11_21  vw_route_11_21  we_route  iwrite_route_11_21  vss  sky130_fd_pr__nfet_01v8  w=0.5  l=0.5
X_rhebb_11_21  iwrite_route_11_21  inp_upper_21  ierr_dig_11  vcm_route  vdd vss  hebbian_mult
XMPRED_r_11_22  i_pred_11  vw_route_11_22  vss  vss  sky130_fd_pr__nfet_01v8  w=4  l=0.35
Cw_route_11_22  vw_route_11_22  vss  200f
R_bleed_11_22  vw_route_11_22  vss  10000meg
XMN4_r_11_22  vw_route_11_22  we_route  iwrite_route_11_22  vss  sky130_fd_pr__nfet_01v8  w=0.5  l=0.5
X_rhebb_11_22  iwrite_route_11_22  inp_upper_22  ierr_dig_11  vcm_route  vdd vss  hebbian_mult
XMPRED_r_11_23  i_pred_11  vw_route_11_23  vss  vss  sky130_fd_pr__nfet_01v8  w=4  l=0.35
Cw_route_11_23  vw_route_11_23  vss  200f
R_bleed_11_23  vw_route_11_23  vss  10000meg
XMN4_r_11_23  vw_route_11_23  we_route  iwrite_route_11_23  vss  sky130_fd_pr__nfet_01v8  w=0.5  l=0.5
X_rhebb_11_23  iwrite_route_11_23  inp_upper_23  ierr_dig_11  vcm_route  vdd vss  hebbian_mult
XMPRED_r_11_24  i_pred_11  vw_route_11_24  vss  vss  sky130_fd_pr__nfet_01v8  w=4  l=0.35
Cw_route_11_24  vw_route_11_24  vss  200f
R_bleed_11_24  vw_route_11_24  vss  10000meg
XMN4_r_11_24  vw_route_11_24  we_route  iwrite_route_11_24  vss  sky130_fd_pr__nfet_01v8  w=0.5  l=0.5
X_rhebb_11_24  iwrite_route_11_24  inp_upper_24  ierr_dig_11  vcm_route  vdd vss  hebbian_mult
XMPRED_r_11_25  i_pred_11  vw_route_11_25  vss  vss  sky130_fd_pr__nfet_01v8  w=4  l=0.35
Cw_route_11_25  vw_route_11_25  vss  200f
R_bleed_11_25  vw_route_11_25  vss  10000meg
XMN4_r_11_25  vw_route_11_25  we_route  iwrite_route_11_25  vss  sky130_fd_pr__nfet_01v8  w=0.5  l=0.5
X_rhebb_11_25  iwrite_route_11_25  inp_upper_25  ierr_dig_11  vcm_route  vdd vss  hebbian_mult
XMPRED_r_11_26  i_pred_11  vw_route_11_26  vss  vss  sky130_fd_pr__nfet_01v8  w=4  l=0.35
Cw_route_11_26  vw_route_11_26  vss  200f
R_bleed_11_26  vw_route_11_26  vss  10000meg
XMN4_r_11_26  vw_route_11_26  we_route  iwrite_route_11_26  vss  sky130_fd_pr__nfet_01v8  w=0.5  l=0.5
X_rhebb_11_26  iwrite_route_11_26  inp_upper_26  ierr_dig_11  vcm_route  vdd vss  hebbian_mult
XMPRED_r_11_27  i_pred_11  vw_route_11_27  vss  vss  sky130_fd_pr__nfet_01v8  w=4  l=0.35
Cw_route_11_27  vw_route_11_27  vss  200f
R_bleed_11_27  vw_route_11_27  vss  10000meg
XMN4_r_11_27  vw_route_11_27  we_route  iwrite_route_11_27  vss  sky130_fd_pr__nfet_01v8  w=0.5  l=0.5
X_rhebb_11_27  iwrite_route_11_27  inp_upper_27  ierr_dig_11  vcm_route  vdd vss  hebbian_mult
XMPRED_r_11_28  i_pred_11  vw_route_11_28  vss  vss  sky130_fd_pr__nfet_01v8  w=4  l=0.35
Cw_route_11_28  vw_route_11_28  vss  200f
R_bleed_11_28  vw_route_11_28  vss  10000meg
XMN4_r_11_28  vw_route_11_28  we_route  iwrite_route_11_28  vss  sky130_fd_pr__nfet_01v8  w=0.5  l=0.5
X_rhebb_11_28  iwrite_route_11_28  inp_upper_28  ierr_dig_11  vcm_route  vdd vss  hebbian_mult
XMPRED_r_11_29  i_pred_11  vw_route_11_29  vss  vss  sky130_fd_pr__nfet_01v8  w=4  l=0.35
Cw_route_11_29  vw_route_11_29  vss  200f
R_bleed_11_29  vw_route_11_29  vss  10000meg
XMN4_r_11_29  vw_route_11_29  we_route  iwrite_route_11_29  vss  sky130_fd_pr__nfet_01v8  w=0.5  l=0.5
X_rhebb_11_29  iwrite_route_11_29  inp_upper_29  ierr_dig_11  vcm_route  vdd vss  hebbian_mult
XMPRED_r_11_30  i_pred_11  vw_route_11_30  vss  vss  sky130_fd_pr__nfet_01v8  w=4  l=0.35
Cw_route_11_30  vw_route_11_30  vss  200f
R_bleed_11_30  vw_route_11_30  vss  10000meg
XMN4_r_11_30  vw_route_11_30  we_route  iwrite_route_11_30  vss  sky130_fd_pr__nfet_01v8  w=0.5  l=0.5
X_rhebb_11_30  iwrite_route_11_30  inp_upper_30  ierr_dig_11  vcm_route  vdd vss  hebbian_mult
XMPRED_r_11_31  i_pred_11  vw_route_11_31  vss  vss  sky130_fd_pr__nfet_01v8  w=4  l=0.35
Cw_route_11_31  vw_route_11_31  vss  200f
R_bleed_11_31  vw_route_11_31  vss  10000meg
XMN4_r_11_31  vw_route_11_31  we_route  iwrite_route_11_31  vss  sky130_fd_pr__nfet_01v8  w=0.5  l=0.5
X_rhebb_11_31  iwrite_route_11_31  inp_upper_31  ierr_dig_11  vcm_route  vdd vss  hebbian_mult

* ── Destination row 12 ── 32 source connections ──────────────────────────
XMPRED_r_12_0  i_pred_12  vw_route_12_0  vss  vss  sky130_fd_pr__nfet_01v8  w=4  l=0.35
Cw_route_12_0  vw_route_12_0  vss  200f
R_bleed_12_0  vw_route_12_0  vss  10000meg
XMN4_r_12_0  vw_route_12_0  we_route  iwrite_route_12_0  vss  sky130_fd_pr__nfet_01v8  w=0.5  l=0.5
X_rhebb_12_0  iwrite_route_12_0  inp_upper_0  ierr_dig_12  vcm_route  vdd vss  hebbian_mult
XMPRED_r_12_1  i_pred_12  vw_route_12_1  vss  vss  sky130_fd_pr__nfet_01v8  w=4  l=0.35
Cw_route_12_1  vw_route_12_1  vss  200f
R_bleed_12_1  vw_route_12_1  vss  10000meg
XMN4_r_12_1  vw_route_12_1  we_route  iwrite_route_12_1  vss  sky130_fd_pr__nfet_01v8  w=0.5  l=0.5
X_rhebb_12_1  iwrite_route_12_1  inp_upper_1  ierr_dig_12  vcm_route  vdd vss  hebbian_mult
XMPRED_r_12_2  i_pred_12  vw_route_12_2  vss  vss  sky130_fd_pr__nfet_01v8  w=4  l=0.35
Cw_route_12_2  vw_route_12_2  vss  200f
R_bleed_12_2  vw_route_12_2  vss  10000meg
XMN4_r_12_2  vw_route_12_2  we_route  iwrite_route_12_2  vss  sky130_fd_pr__nfet_01v8  w=0.5  l=0.5
X_rhebb_12_2  iwrite_route_12_2  inp_upper_2  ierr_dig_12  vcm_route  vdd vss  hebbian_mult
XMPRED_r_12_3  i_pred_12  vw_route_12_3  vss  vss  sky130_fd_pr__nfet_01v8  w=4  l=0.35
Cw_route_12_3  vw_route_12_3  vss  200f
R_bleed_12_3  vw_route_12_3  vss  10000meg
XMN4_r_12_3  vw_route_12_3  we_route  iwrite_route_12_3  vss  sky130_fd_pr__nfet_01v8  w=0.5  l=0.5
X_rhebb_12_3  iwrite_route_12_3  inp_upper_3  ierr_dig_12  vcm_route  vdd vss  hebbian_mult
XMPRED_r_12_4  i_pred_12  vw_route_12_4  vss  vss  sky130_fd_pr__nfet_01v8  w=4  l=0.35
Cw_route_12_4  vw_route_12_4  vss  200f
R_bleed_12_4  vw_route_12_4  vss  10000meg
XMN4_r_12_4  vw_route_12_4  we_route  iwrite_route_12_4  vss  sky130_fd_pr__nfet_01v8  w=0.5  l=0.5
X_rhebb_12_4  iwrite_route_12_4  inp_upper_4  ierr_dig_12  vcm_route  vdd vss  hebbian_mult
XMPRED_r_12_5  i_pred_12  vw_route_12_5  vss  vss  sky130_fd_pr__nfet_01v8  w=4  l=0.35
Cw_route_12_5  vw_route_12_5  vss  200f
R_bleed_12_5  vw_route_12_5  vss  10000meg
XMN4_r_12_5  vw_route_12_5  we_route  iwrite_route_12_5  vss  sky130_fd_pr__nfet_01v8  w=0.5  l=0.5
X_rhebb_12_5  iwrite_route_12_5  inp_upper_5  ierr_dig_12  vcm_route  vdd vss  hebbian_mult
XMPRED_r_12_6  i_pred_12  vw_route_12_6  vss  vss  sky130_fd_pr__nfet_01v8  w=4  l=0.35
Cw_route_12_6  vw_route_12_6  vss  200f
R_bleed_12_6  vw_route_12_6  vss  10000meg
XMN4_r_12_6  vw_route_12_6  we_route  iwrite_route_12_6  vss  sky130_fd_pr__nfet_01v8  w=0.5  l=0.5
X_rhebb_12_6  iwrite_route_12_6  inp_upper_6  ierr_dig_12  vcm_route  vdd vss  hebbian_mult
XMPRED_r_12_7  i_pred_12  vw_route_12_7  vss  vss  sky130_fd_pr__nfet_01v8  w=4  l=0.35
Cw_route_12_7  vw_route_12_7  vss  200f
R_bleed_12_7  vw_route_12_7  vss  10000meg
XMN4_r_12_7  vw_route_12_7  we_route  iwrite_route_12_7  vss  sky130_fd_pr__nfet_01v8  w=0.5  l=0.5
X_rhebb_12_7  iwrite_route_12_7  inp_upper_7  ierr_dig_12  vcm_route  vdd vss  hebbian_mult
XMPRED_r_12_8  i_pred_12  vw_route_12_8  vss  vss  sky130_fd_pr__nfet_01v8  w=4  l=0.35
Cw_route_12_8  vw_route_12_8  vss  200f
R_bleed_12_8  vw_route_12_8  vss  10000meg
XMN4_r_12_8  vw_route_12_8  we_route  iwrite_route_12_8  vss  sky130_fd_pr__nfet_01v8  w=0.5  l=0.5
X_rhebb_12_8  iwrite_route_12_8  inp_upper_8  ierr_dig_12  vcm_route  vdd vss  hebbian_mult
XMPRED_r_12_9  i_pred_12  vw_route_12_9  vss  vss  sky130_fd_pr__nfet_01v8  w=4  l=0.35
Cw_route_12_9  vw_route_12_9  vss  200f
R_bleed_12_9  vw_route_12_9  vss  10000meg
XMN4_r_12_9  vw_route_12_9  we_route  iwrite_route_12_9  vss  sky130_fd_pr__nfet_01v8  w=0.5  l=0.5
X_rhebb_12_9  iwrite_route_12_9  inp_upper_9  ierr_dig_12  vcm_route  vdd vss  hebbian_mult
XMPRED_r_12_10  i_pred_12  vw_route_12_10  vss  vss  sky130_fd_pr__nfet_01v8  w=4  l=0.35
Cw_route_12_10  vw_route_12_10  vss  200f
R_bleed_12_10  vw_route_12_10  vss  10000meg
XMN4_r_12_10  vw_route_12_10  we_route  iwrite_route_12_10  vss  sky130_fd_pr__nfet_01v8  w=0.5  l=0.5
X_rhebb_12_10  iwrite_route_12_10  inp_upper_10  ierr_dig_12  vcm_route  vdd vss  hebbian_mult
XMPRED_r_12_11  i_pred_12  vw_route_12_11  vss  vss  sky130_fd_pr__nfet_01v8  w=4  l=0.35
Cw_route_12_11  vw_route_12_11  vss  200f
R_bleed_12_11  vw_route_12_11  vss  10000meg
XMN4_r_12_11  vw_route_12_11  we_route  iwrite_route_12_11  vss  sky130_fd_pr__nfet_01v8  w=0.5  l=0.5
X_rhebb_12_11  iwrite_route_12_11  inp_upper_11  ierr_dig_12  vcm_route  vdd vss  hebbian_mult
XMPRED_r_12_12  i_pred_12  vw_route_12_12  vss  vss  sky130_fd_pr__nfet_01v8  w=4  l=0.35
Cw_route_12_12  vw_route_12_12  vss  200f
R_bleed_12_12  vw_route_12_12  vss  10000meg
XMN4_r_12_12  vw_route_12_12  we_route  iwrite_route_12_12  vss  sky130_fd_pr__nfet_01v8  w=0.5  l=0.5
X_rhebb_12_12  iwrite_route_12_12  inp_upper_12  ierr_dig_12  vcm_route  vdd vss  hebbian_mult
XMPRED_r_12_13  i_pred_12  vw_route_12_13  vss  vss  sky130_fd_pr__nfet_01v8  w=4  l=0.35
Cw_route_12_13  vw_route_12_13  vss  200f
R_bleed_12_13  vw_route_12_13  vss  10000meg
XMN4_r_12_13  vw_route_12_13  we_route  iwrite_route_12_13  vss  sky130_fd_pr__nfet_01v8  w=0.5  l=0.5
X_rhebb_12_13  iwrite_route_12_13  inp_upper_13  ierr_dig_12  vcm_route  vdd vss  hebbian_mult
XMPRED_r_12_14  i_pred_12  vw_route_12_14  vss  vss  sky130_fd_pr__nfet_01v8  w=4  l=0.35
Cw_route_12_14  vw_route_12_14  vss  200f
R_bleed_12_14  vw_route_12_14  vss  10000meg
XMN4_r_12_14  vw_route_12_14  we_route  iwrite_route_12_14  vss  sky130_fd_pr__nfet_01v8  w=0.5  l=0.5
X_rhebb_12_14  iwrite_route_12_14  inp_upper_14  ierr_dig_12  vcm_route  vdd vss  hebbian_mult
XMPRED_r_12_15  i_pred_12  vw_route_12_15  vss  vss  sky130_fd_pr__nfet_01v8  w=4  l=0.35
Cw_route_12_15  vw_route_12_15  vss  200f
R_bleed_12_15  vw_route_12_15  vss  10000meg
XMN4_r_12_15  vw_route_12_15  we_route  iwrite_route_12_15  vss  sky130_fd_pr__nfet_01v8  w=0.5  l=0.5
X_rhebb_12_15  iwrite_route_12_15  inp_upper_15  ierr_dig_12  vcm_route  vdd vss  hebbian_mult
XMPRED_r_12_16  i_pred_12  vw_route_12_16  vss  vss  sky130_fd_pr__nfet_01v8  w=4  l=0.35
Cw_route_12_16  vw_route_12_16  vss  200f
R_bleed_12_16  vw_route_12_16  vss  10000meg
XMN4_r_12_16  vw_route_12_16  we_route  iwrite_route_12_16  vss  sky130_fd_pr__nfet_01v8  w=0.5  l=0.5
X_rhebb_12_16  iwrite_route_12_16  inp_upper_16  ierr_dig_12  vcm_route  vdd vss  hebbian_mult
XMPRED_r_12_17  i_pred_12  vw_route_12_17  vss  vss  sky130_fd_pr__nfet_01v8  w=4  l=0.35
Cw_route_12_17  vw_route_12_17  vss  200f
R_bleed_12_17  vw_route_12_17  vss  10000meg
XMN4_r_12_17  vw_route_12_17  we_route  iwrite_route_12_17  vss  sky130_fd_pr__nfet_01v8  w=0.5  l=0.5
X_rhebb_12_17  iwrite_route_12_17  inp_upper_17  ierr_dig_12  vcm_route  vdd vss  hebbian_mult
XMPRED_r_12_18  i_pred_12  vw_route_12_18  vss  vss  sky130_fd_pr__nfet_01v8  w=4  l=0.35
Cw_route_12_18  vw_route_12_18  vss  200f
R_bleed_12_18  vw_route_12_18  vss  10000meg
XMN4_r_12_18  vw_route_12_18  we_route  iwrite_route_12_18  vss  sky130_fd_pr__nfet_01v8  w=0.5  l=0.5
X_rhebb_12_18  iwrite_route_12_18  inp_upper_18  ierr_dig_12  vcm_route  vdd vss  hebbian_mult
XMPRED_r_12_19  i_pred_12  vw_route_12_19  vss  vss  sky130_fd_pr__nfet_01v8  w=4  l=0.35
Cw_route_12_19  vw_route_12_19  vss  200f
R_bleed_12_19  vw_route_12_19  vss  10000meg
XMN4_r_12_19  vw_route_12_19  we_route  iwrite_route_12_19  vss  sky130_fd_pr__nfet_01v8  w=0.5  l=0.5
X_rhebb_12_19  iwrite_route_12_19  inp_upper_19  ierr_dig_12  vcm_route  vdd vss  hebbian_mult
XMPRED_r_12_20  i_pred_12  vw_route_12_20  vss  vss  sky130_fd_pr__nfet_01v8  w=4  l=0.35
Cw_route_12_20  vw_route_12_20  vss  200f
R_bleed_12_20  vw_route_12_20  vss  10000meg
XMN4_r_12_20  vw_route_12_20  we_route  iwrite_route_12_20  vss  sky130_fd_pr__nfet_01v8  w=0.5  l=0.5
X_rhebb_12_20  iwrite_route_12_20  inp_upper_20  ierr_dig_12  vcm_route  vdd vss  hebbian_mult
XMPRED_r_12_21  i_pred_12  vw_route_12_21  vss  vss  sky130_fd_pr__nfet_01v8  w=4  l=0.35
Cw_route_12_21  vw_route_12_21  vss  200f
R_bleed_12_21  vw_route_12_21  vss  10000meg
XMN4_r_12_21  vw_route_12_21  we_route  iwrite_route_12_21  vss  sky130_fd_pr__nfet_01v8  w=0.5  l=0.5
X_rhebb_12_21  iwrite_route_12_21  inp_upper_21  ierr_dig_12  vcm_route  vdd vss  hebbian_mult
XMPRED_r_12_22  i_pred_12  vw_route_12_22  vss  vss  sky130_fd_pr__nfet_01v8  w=4  l=0.35
Cw_route_12_22  vw_route_12_22  vss  200f
R_bleed_12_22  vw_route_12_22  vss  10000meg
XMN4_r_12_22  vw_route_12_22  we_route  iwrite_route_12_22  vss  sky130_fd_pr__nfet_01v8  w=0.5  l=0.5
X_rhebb_12_22  iwrite_route_12_22  inp_upper_22  ierr_dig_12  vcm_route  vdd vss  hebbian_mult
XMPRED_r_12_23  i_pred_12  vw_route_12_23  vss  vss  sky130_fd_pr__nfet_01v8  w=4  l=0.35
Cw_route_12_23  vw_route_12_23  vss  200f
R_bleed_12_23  vw_route_12_23  vss  10000meg
XMN4_r_12_23  vw_route_12_23  we_route  iwrite_route_12_23  vss  sky130_fd_pr__nfet_01v8  w=0.5  l=0.5
X_rhebb_12_23  iwrite_route_12_23  inp_upper_23  ierr_dig_12  vcm_route  vdd vss  hebbian_mult
XMPRED_r_12_24  i_pred_12  vw_route_12_24  vss  vss  sky130_fd_pr__nfet_01v8  w=4  l=0.35
Cw_route_12_24  vw_route_12_24  vss  200f
R_bleed_12_24  vw_route_12_24  vss  10000meg
XMN4_r_12_24  vw_route_12_24  we_route  iwrite_route_12_24  vss  sky130_fd_pr__nfet_01v8  w=0.5  l=0.5
X_rhebb_12_24  iwrite_route_12_24  inp_upper_24  ierr_dig_12  vcm_route  vdd vss  hebbian_mult
XMPRED_r_12_25  i_pred_12  vw_route_12_25  vss  vss  sky130_fd_pr__nfet_01v8  w=4  l=0.35
Cw_route_12_25  vw_route_12_25  vss  200f
R_bleed_12_25  vw_route_12_25  vss  10000meg
XMN4_r_12_25  vw_route_12_25  we_route  iwrite_route_12_25  vss  sky130_fd_pr__nfet_01v8  w=0.5  l=0.5
X_rhebb_12_25  iwrite_route_12_25  inp_upper_25  ierr_dig_12  vcm_route  vdd vss  hebbian_mult
XMPRED_r_12_26  i_pred_12  vw_route_12_26  vss  vss  sky130_fd_pr__nfet_01v8  w=4  l=0.35
Cw_route_12_26  vw_route_12_26  vss  200f
R_bleed_12_26  vw_route_12_26  vss  10000meg
XMN4_r_12_26  vw_route_12_26  we_route  iwrite_route_12_26  vss  sky130_fd_pr__nfet_01v8  w=0.5  l=0.5
X_rhebb_12_26  iwrite_route_12_26  inp_upper_26  ierr_dig_12  vcm_route  vdd vss  hebbian_mult
XMPRED_r_12_27  i_pred_12  vw_route_12_27  vss  vss  sky130_fd_pr__nfet_01v8  w=4  l=0.35
Cw_route_12_27  vw_route_12_27  vss  200f
R_bleed_12_27  vw_route_12_27  vss  10000meg
XMN4_r_12_27  vw_route_12_27  we_route  iwrite_route_12_27  vss  sky130_fd_pr__nfet_01v8  w=0.5  l=0.5
X_rhebb_12_27  iwrite_route_12_27  inp_upper_27  ierr_dig_12  vcm_route  vdd vss  hebbian_mult
XMPRED_r_12_28  i_pred_12  vw_route_12_28  vss  vss  sky130_fd_pr__nfet_01v8  w=4  l=0.35
Cw_route_12_28  vw_route_12_28  vss  200f
R_bleed_12_28  vw_route_12_28  vss  10000meg
XMN4_r_12_28  vw_route_12_28  we_route  iwrite_route_12_28  vss  sky130_fd_pr__nfet_01v8  w=0.5  l=0.5
X_rhebb_12_28  iwrite_route_12_28  inp_upper_28  ierr_dig_12  vcm_route  vdd vss  hebbian_mult
XMPRED_r_12_29  i_pred_12  vw_route_12_29  vss  vss  sky130_fd_pr__nfet_01v8  w=4  l=0.35
Cw_route_12_29  vw_route_12_29  vss  200f
R_bleed_12_29  vw_route_12_29  vss  10000meg
XMN4_r_12_29  vw_route_12_29  we_route  iwrite_route_12_29  vss  sky130_fd_pr__nfet_01v8  w=0.5  l=0.5
X_rhebb_12_29  iwrite_route_12_29  inp_upper_29  ierr_dig_12  vcm_route  vdd vss  hebbian_mult
XMPRED_r_12_30  i_pred_12  vw_route_12_30  vss  vss  sky130_fd_pr__nfet_01v8  w=4  l=0.35
Cw_route_12_30  vw_route_12_30  vss  200f
R_bleed_12_30  vw_route_12_30  vss  10000meg
XMN4_r_12_30  vw_route_12_30  we_route  iwrite_route_12_30  vss  sky130_fd_pr__nfet_01v8  w=0.5  l=0.5
X_rhebb_12_30  iwrite_route_12_30  inp_upper_30  ierr_dig_12  vcm_route  vdd vss  hebbian_mult
XMPRED_r_12_31  i_pred_12  vw_route_12_31  vss  vss  sky130_fd_pr__nfet_01v8  w=4  l=0.35
Cw_route_12_31  vw_route_12_31  vss  200f
R_bleed_12_31  vw_route_12_31  vss  10000meg
XMN4_r_12_31  vw_route_12_31  we_route  iwrite_route_12_31  vss  sky130_fd_pr__nfet_01v8  w=0.5  l=0.5
X_rhebb_12_31  iwrite_route_12_31  inp_upper_31  ierr_dig_12  vcm_route  vdd vss  hebbian_mult

* ── Destination row 13 ── 32 source connections ──────────────────────────
XMPRED_r_13_0  i_pred_13  vw_route_13_0  vss  vss  sky130_fd_pr__nfet_01v8  w=4  l=0.35
Cw_route_13_0  vw_route_13_0  vss  200f
R_bleed_13_0  vw_route_13_0  vss  10000meg
XMN4_r_13_0  vw_route_13_0  we_route  iwrite_route_13_0  vss  sky130_fd_pr__nfet_01v8  w=0.5  l=0.5
X_rhebb_13_0  iwrite_route_13_0  inp_upper_0  ierr_dig_13  vcm_route  vdd vss  hebbian_mult
XMPRED_r_13_1  i_pred_13  vw_route_13_1  vss  vss  sky130_fd_pr__nfet_01v8  w=4  l=0.35
Cw_route_13_1  vw_route_13_1  vss  200f
R_bleed_13_1  vw_route_13_1  vss  10000meg
XMN4_r_13_1  vw_route_13_1  we_route  iwrite_route_13_1  vss  sky130_fd_pr__nfet_01v8  w=0.5  l=0.5
X_rhebb_13_1  iwrite_route_13_1  inp_upper_1  ierr_dig_13  vcm_route  vdd vss  hebbian_mult
XMPRED_r_13_2  i_pred_13  vw_route_13_2  vss  vss  sky130_fd_pr__nfet_01v8  w=4  l=0.35
Cw_route_13_2  vw_route_13_2  vss  200f
R_bleed_13_2  vw_route_13_2  vss  10000meg
XMN4_r_13_2  vw_route_13_2  we_route  iwrite_route_13_2  vss  sky130_fd_pr__nfet_01v8  w=0.5  l=0.5
X_rhebb_13_2  iwrite_route_13_2  inp_upper_2  ierr_dig_13  vcm_route  vdd vss  hebbian_mult
XMPRED_r_13_3  i_pred_13  vw_route_13_3  vss  vss  sky130_fd_pr__nfet_01v8  w=4  l=0.35
Cw_route_13_3  vw_route_13_3  vss  200f
R_bleed_13_3  vw_route_13_3  vss  10000meg
XMN4_r_13_3  vw_route_13_3  we_route  iwrite_route_13_3  vss  sky130_fd_pr__nfet_01v8  w=0.5  l=0.5
X_rhebb_13_3  iwrite_route_13_3  inp_upper_3  ierr_dig_13  vcm_route  vdd vss  hebbian_mult
XMPRED_r_13_4  i_pred_13  vw_route_13_4  vss  vss  sky130_fd_pr__nfet_01v8  w=4  l=0.35
Cw_route_13_4  vw_route_13_4  vss  200f
R_bleed_13_4  vw_route_13_4  vss  10000meg
XMN4_r_13_4  vw_route_13_4  we_route  iwrite_route_13_4  vss  sky130_fd_pr__nfet_01v8  w=0.5  l=0.5
X_rhebb_13_4  iwrite_route_13_4  inp_upper_4  ierr_dig_13  vcm_route  vdd vss  hebbian_mult
XMPRED_r_13_5  i_pred_13  vw_route_13_5  vss  vss  sky130_fd_pr__nfet_01v8  w=4  l=0.35
Cw_route_13_5  vw_route_13_5  vss  200f
R_bleed_13_5  vw_route_13_5  vss  10000meg
XMN4_r_13_5  vw_route_13_5  we_route  iwrite_route_13_5  vss  sky130_fd_pr__nfet_01v8  w=0.5  l=0.5
X_rhebb_13_5  iwrite_route_13_5  inp_upper_5  ierr_dig_13  vcm_route  vdd vss  hebbian_mult
XMPRED_r_13_6  i_pred_13  vw_route_13_6  vss  vss  sky130_fd_pr__nfet_01v8  w=4  l=0.35
Cw_route_13_6  vw_route_13_6  vss  200f
R_bleed_13_6  vw_route_13_6  vss  10000meg
XMN4_r_13_6  vw_route_13_6  we_route  iwrite_route_13_6  vss  sky130_fd_pr__nfet_01v8  w=0.5  l=0.5
X_rhebb_13_6  iwrite_route_13_6  inp_upper_6  ierr_dig_13  vcm_route  vdd vss  hebbian_mult
XMPRED_r_13_7  i_pred_13  vw_route_13_7  vss  vss  sky130_fd_pr__nfet_01v8  w=4  l=0.35
Cw_route_13_7  vw_route_13_7  vss  200f
R_bleed_13_7  vw_route_13_7  vss  10000meg
XMN4_r_13_7  vw_route_13_7  we_route  iwrite_route_13_7  vss  sky130_fd_pr__nfet_01v8  w=0.5  l=0.5
X_rhebb_13_7  iwrite_route_13_7  inp_upper_7  ierr_dig_13  vcm_route  vdd vss  hebbian_mult
XMPRED_r_13_8  i_pred_13  vw_route_13_8  vss  vss  sky130_fd_pr__nfet_01v8  w=4  l=0.35
Cw_route_13_8  vw_route_13_8  vss  200f
R_bleed_13_8  vw_route_13_8  vss  10000meg
XMN4_r_13_8  vw_route_13_8  we_route  iwrite_route_13_8  vss  sky130_fd_pr__nfet_01v8  w=0.5  l=0.5
X_rhebb_13_8  iwrite_route_13_8  inp_upper_8  ierr_dig_13  vcm_route  vdd vss  hebbian_mult
XMPRED_r_13_9  i_pred_13  vw_route_13_9  vss  vss  sky130_fd_pr__nfet_01v8  w=4  l=0.35
Cw_route_13_9  vw_route_13_9  vss  200f
R_bleed_13_9  vw_route_13_9  vss  10000meg
XMN4_r_13_9  vw_route_13_9  we_route  iwrite_route_13_9  vss  sky130_fd_pr__nfet_01v8  w=0.5  l=0.5
X_rhebb_13_9  iwrite_route_13_9  inp_upper_9  ierr_dig_13  vcm_route  vdd vss  hebbian_mult
XMPRED_r_13_10  i_pred_13  vw_route_13_10  vss  vss  sky130_fd_pr__nfet_01v8  w=4  l=0.35
Cw_route_13_10  vw_route_13_10  vss  200f
R_bleed_13_10  vw_route_13_10  vss  10000meg
XMN4_r_13_10  vw_route_13_10  we_route  iwrite_route_13_10  vss  sky130_fd_pr__nfet_01v8  w=0.5  l=0.5
X_rhebb_13_10  iwrite_route_13_10  inp_upper_10  ierr_dig_13  vcm_route  vdd vss  hebbian_mult
XMPRED_r_13_11  i_pred_13  vw_route_13_11  vss  vss  sky130_fd_pr__nfet_01v8  w=4  l=0.35
Cw_route_13_11  vw_route_13_11  vss  200f
R_bleed_13_11  vw_route_13_11  vss  10000meg
XMN4_r_13_11  vw_route_13_11  we_route  iwrite_route_13_11  vss  sky130_fd_pr__nfet_01v8  w=0.5  l=0.5
X_rhebb_13_11  iwrite_route_13_11  inp_upper_11  ierr_dig_13  vcm_route  vdd vss  hebbian_mult
XMPRED_r_13_12  i_pred_13  vw_route_13_12  vss  vss  sky130_fd_pr__nfet_01v8  w=4  l=0.35
Cw_route_13_12  vw_route_13_12  vss  200f
R_bleed_13_12  vw_route_13_12  vss  10000meg
XMN4_r_13_12  vw_route_13_12  we_route  iwrite_route_13_12  vss  sky130_fd_pr__nfet_01v8  w=0.5  l=0.5
X_rhebb_13_12  iwrite_route_13_12  inp_upper_12  ierr_dig_13  vcm_route  vdd vss  hebbian_mult
XMPRED_r_13_13  i_pred_13  vw_route_13_13  vss  vss  sky130_fd_pr__nfet_01v8  w=4  l=0.35
Cw_route_13_13  vw_route_13_13  vss  200f
R_bleed_13_13  vw_route_13_13  vss  10000meg
XMN4_r_13_13  vw_route_13_13  we_route  iwrite_route_13_13  vss  sky130_fd_pr__nfet_01v8  w=0.5  l=0.5
X_rhebb_13_13  iwrite_route_13_13  inp_upper_13  ierr_dig_13  vcm_route  vdd vss  hebbian_mult
XMPRED_r_13_14  i_pred_13  vw_route_13_14  vss  vss  sky130_fd_pr__nfet_01v8  w=4  l=0.35
Cw_route_13_14  vw_route_13_14  vss  200f
R_bleed_13_14  vw_route_13_14  vss  10000meg
XMN4_r_13_14  vw_route_13_14  we_route  iwrite_route_13_14  vss  sky130_fd_pr__nfet_01v8  w=0.5  l=0.5
X_rhebb_13_14  iwrite_route_13_14  inp_upper_14  ierr_dig_13  vcm_route  vdd vss  hebbian_mult
XMPRED_r_13_15  i_pred_13  vw_route_13_15  vss  vss  sky130_fd_pr__nfet_01v8  w=4  l=0.35
Cw_route_13_15  vw_route_13_15  vss  200f
R_bleed_13_15  vw_route_13_15  vss  10000meg
XMN4_r_13_15  vw_route_13_15  we_route  iwrite_route_13_15  vss  sky130_fd_pr__nfet_01v8  w=0.5  l=0.5
X_rhebb_13_15  iwrite_route_13_15  inp_upper_15  ierr_dig_13  vcm_route  vdd vss  hebbian_mult
XMPRED_r_13_16  i_pred_13  vw_route_13_16  vss  vss  sky130_fd_pr__nfet_01v8  w=4  l=0.35
Cw_route_13_16  vw_route_13_16  vss  200f
R_bleed_13_16  vw_route_13_16  vss  10000meg
XMN4_r_13_16  vw_route_13_16  we_route  iwrite_route_13_16  vss  sky130_fd_pr__nfet_01v8  w=0.5  l=0.5
X_rhebb_13_16  iwrite_route_13_16  inp_upper_16  ierr_dig_13  vcm_route  vdd vss  hebbian_mult
XMPRED_r_13_17  i_pred_13  vw_route_13_17  vss  vss  sky130_fd_pr__nfet_01v8  w=4  l=0.35
Cw_route_13_17  vw_route_13_17  vss  200f
R_bleed_13_17  vw_route_13_17  vss  10000meg
XMN4_r_13_17  vw_route_13_17  we_route  iwrite_route_13_17  vss  sky130_fd_pr__nfet_01v8  w=0.5  l=0.5
X_rhebb_13_17  iwrite_route_13_17  inp_upper_17  ierr_dig_13  vcm_route  vdd vss  hebbian_mult
XMPRED_r_13_18  i_pred_13  vw_route_13_18  vss  vss  sky130_fd_pr__nfet_01v8  w=4  l=0.35
Cw_route_13_18  vw_route_13_18  vss  200f
R_bleed_13_18  vw_route_13_18  vss  10000meg
XMN4_r_13_18  vw_route_13_18  we_route  iwrite_route_13_18  vss  sky130_fd_pr__nfet_01v8  w=0.5  l=0.5
X_rhebb_13_18  iwrite_route_13_18  inp_upper_18  ierr_dig_13  vcm_route  vdd vss  hebbian_mult
XMPRED_r_13_19  i_pred_13  vw_route_13_19  vss  vss  sky130_fd_pr__nfet_01v8  w=4  l=0.35
Cw_route_13_19  vw_route_13_19  vss  200f
R_bleed_13_19  vw_route_13_19  vss  10000meg
XMN4_r_13_19  vw_route_13_19  we_route  iwrite_route_13_19  vss  sky130_fd_pr__nfet_01v8  w=0.5  l=0.5
X_rhebb_13_19  iwrite_route_13_19  inp_upper_19  ierr_dig_13  vcm_route  vdd vss  hebbian_mult
XMPRED_r_13_20  i_pred_13  vw_route_13_20  vss  vss  sky130_fd_pr__nfet_01v8  w=4  l=0.35
Cw_route_13_20  vw_route_13_20  vss  200f
R_bleed_13_20  vw_route_13_20  vss  10000meg
XMN4_r_13_20  vw_route_13_20  we_route  iwrite_route_13_20  vss  sky130_fd_pr__nfet_01v8  w=0.5  l=0.5
X_rhebb_13_20  iwrite_route_13_20  inp_upper_20  ierr_dig_13  vcm_route  vdd vss  hebbian_mult
XMPRED_r_13_21  i_pred_13  vw_route_13_21  vss  vss  sky130_fd_pr__nfet_01v8  w=4  l=0.35
Cw_route_13_21  vw_route_13_21  vss  200f
R_bleed_13_21  vw_route_13_21  vss  10000meg
XMN4_r_13_21  vw_route_13_21  we_route  iwrite_route_13_21  vss  sky130_fd_pr__nfet_01v8  w=0.5  l=0.5
X_rhebb_13_21  iwrite_route_13_21  inp_upper_21  ierr_dig_13  vcm_route  vdd vss  hebbian_mult
XMPRED_r_13_22  i_pred_13  vw_route_13_22  vss  vss  sky130_fd_pr__nfet_01v8  w=4  l=0.35
Cw_route_13_22  vw_route_13_22  vss  200f
R_bleed_13_22  vw_route_13_22  vss  10000meg
XMN4_r_13_22  vw_route_13_22  we_route  iwrite_route_13_22  vss  sky130_fd_pr__nfet_01v8  w=0.5  l=0.5
X_rhebb_13_22  iwrite_route_13_22  inp_upper_22  ierr_dig_13  vcm_route  vdd vss  hebbian_mult
XMPRED_r_13_23  i_pred_13  vw_route_13_23  vss  vss  sky130_fd_pr__nfet_01v8  w=4  l=0.35
Cw_route_13_23  vw_route_13_23  vss  200f
R_bleed_13_23  vw_route_13_23  vss  10000meg
XMN4_r_13_23  vw_route_13_23  we_route  iwrite_route_13_23  vss  sky130_fd_pr__nfet_01v8  w=0.5  l=0.5
X_rhebb_13_23  iwrite_route_13_23  inp_upper_23  ierr_dig_13  vcm_route  vdd vss  hebbian_mult
XMPRED_r_13_24  i_pred_13  vw_route_13_24  vss  vss  sky130_fd_pr__nfet_01v8  w=4  l=0.35
Cw_route_13_24  vw_route_13_24  vss  200f
R_bleed_13_24  vw_route_13_24  vss  10000meg
XMN4_r_13_24  vw_route_13_24  we_route  iwrite_route_13_24  vss  sky130_fd_pr__nfet_01v8  w=0.5  l=0.5
X_rhebb_13_24  iwrite_route_13_24  inp_upper_24  ierr_dig_13  vcm_route  vdd vss  hebbian_mult
XMPRED_r_13_25  i_pred_13  vw_route_13_25  vss  vss  sky130_fd_pr__nfet_01v8  w=4  l=0.35
Cw_route_13_25  vw_route_13_25  vss  200f
R_bleed_13_25  vw_route_13_25  vss  10000meg
XMN4_r_13_25  vw_route_13_25  we_route  iwrite_route_13_25  vss  sky130_fd_pr__nfet_01v8  w=0.5  l=0.5
X_rhebb_13_25  iwrite_route_13_25  inp_upper_25  ierr_dig_13  vcm_route  vdd vss  hebbian_mult
XMPRED_r_13_26  i_pred_13  vw_route_13_26  vss  vss  sky130_fd_pr__nfet_01v8  w=4  l=0.35
Cw_route_13_26  vw_route_13_26  vss  200f
R_bleed_13_26  vw_route_13_26  vss  10000meg
XMN4_r_13_26  vw_route_13_26  we_route  iwrite_route_13_26  vss  sky130_fd_pr__nfet_01v8  w=0.5  l=0.5
X_rhebb_13_26  iwrite_route_13_26  inp_upper_26  ierr_dig_13  vcm_route  vdd vss  hebbian_mult
XMPRED_r_13_27  i_pred_13  vw_route_13_27  vss  vss  sky130_fd_pr__nfet_01v8  w=4  l=0.35
Cw_route_13_27  vw_route_13_27  vss  200f
R_bleed_13_27  vw_route_13_27  vss  10000meg
XMN4_r_13_27  vw_route_13_27  we_route  iwrite_route_13_27  vss  sky130_fd_pr__nfet_01v8  w=0.5  l=0.5
X_rhebb_13_27  iwrite_route_13_27  inp_upper_27  ierr_dig_13  vcm_route  vdd vss  hebbian_mult
XMPRED_r_13_28  i_pred_13  vw_route_13_28  vss  vss  sky130_fd_pr__nfet_01v8  w=4  l=0.35
Cw_route_13_28  vw_route_13_28  vss  200f
R_bleed_13_28  vw_route_13_28  vss  10000meg
XMN4_r_13_28  vw_route_13_28  we_route  iwrite_route_13_28  vss  sky130_fd_pr__nfet_01v8  w=0.5  l=0.5
X_rhebb_13_28  iwrite_route_13_28  inp_upper_28  ierr_dig_13  vcm_route  vdd vss  hebbian_mult
XMPRED_r_13_29  i_pred_13  vw_route_13_29  vss  vss  sky130_fd_pr__nfet_01v8  w=4  l=0.35
Cw_route_13_29  vw_route_13_29  vss  200f
R_bleed_13_29  vw_route_13_29  vss  10000meg
XMN4_r_13_29  vw_route_13_29  we_route  iwrite_route_13_29  vss  sky130_fd_pr__nfet_01v8  w=0.5  l=0.5
X_rhebb_13_29  iwrite_route_13_29  inp_upper_29  ierr_dig_13  vcm_route  vdd vss  hebbian_mult
XMPRED_r_13_30  i_pred_13  vw_route_13_30  vss  vss  sky130_fd_pr__nfet_01v8  w=4  l=0.35
Cw_route_13_30  vw_route_13_30  vss  200f
R_bleed_13_30  vw_route_13_30  vss  10000meg
XMN4_r_13_30  vw_route_13_30  we_route  iwrite_route_13_30  vss  sky130_fd_pr__nfet_01v8  w=0.5  l=0.5
X_rhebb_13_30  iwrite_route_13_30  inp_upper_30  ierr_dig_13  vcm_route  vdd vss  hebbian_mult
XMPRED_r_13_31  i_pred_13  vw_route_13_31  vss  vss  sky130_fd_pr__nfet_01v8  w=4  l=0.35
Cw_route_13_31  vw_route_13_31  vss  200f
R_bleed_13_31  vw_route_13_31  vss  10000meg
XMN4_r_13_31  vw_route_13_31  we_route  iwrite_route_13_31  vss  sky130_fd_pr__nfet_01v8  w=0.5  l=0.5
X_rhebb_13_31  iwrite_route_13_31  inp_upper_31  ierr_dig_13  vcm_route  vdd vss  hebbian_mult

* ── Destination row 14 ── 32 source connections ──────────────────────────
XMPRED_r_14_0  i_pred_14  vw_route_14_0  vss  vss  sky130_fd_pr__nfet_01v8  w=4  l=0.35
Cw_route_14_0  vw_route_14_0  vss  200f
R_bleed_14_0  vw_route_14_0  vss  10000meg
XMN4_r_14_0  vw_route_14_0  we_route  iwrite_route_14_0  vss  sky130_fd_pr__nfet_01v8  w=0.5  l=0.5
X_rhebb_14_0  iwrite_route_14_0  inp_upper_0  ierr_dig_14  vcm_route  vdd vss  hebbian_mult
XMPRED_r_14_1  i_pred_14  vw_route_14_1  vss  vss  sky130_fd_pr__nfet_01v8  w=4  l=0.35
Cw_route_14_1  vw_route_14_1  vss  200f
R_bleed_14_1  vw_route_14_1  vss  10000meg
XMN4_r_14_1  vw_route_14_1  we_route  iwrite_route_14_1  vss  sky130_fd_pr__nfet_01v8  w=0.5  l=0.5
X_rhebb_14_1  iwrite_route_14_1  inp_upper_1  ierr_dig_14  vcm_route  vdd vss  hebbian_mult
XMPRED_r_14_2  i_pred_14  vw_route_14_2  vss  vss  sky130_fd_pr__nfet_01v8  w=4  l=0.35
Cw_route_14_2  vw_route_14_2  vss  200f
R_bleed_14_2  vw_route_14_2  vss  10000meg
XMN4_r_14_2  vw_route_14_2  we_route  iwrite_route_14_2  vss  sky130_fd_pr__nfet_01v8  w=0.5  l=0.5
X_rhebb_14_2  iwrite_route_14_2  inp_upper_2  ierr_dig_14  vcm_route  vdd vss  hebbian_mult
XMPRED_r_14_3  i_pred_14  vw_route_14_3  vss  vss  sky130_fd_pr__nfet_01v8  w=4  l=0.35
Cw_route_14_3  vw_route_14_3  vss  200f
R_bleed_14_3  vw_route_14_3  vss  10000meg
XMN4_r_14_3  vw_route_14_3  we_route  iwrite_route_14_3  vss  sky130_fd_pr__nfet_01v8  w=0.5  l=0.5
X_rhebb_14_3  iwrite_route_14_3  inp_upper_3  ierr_dig_14  vcm_route  vdd vss  hebbian_mult
XMPRED_r_14_4  i_pred_14  vw_route_14_4  vss  vss  sky130_fd_pr__nfet_01v8  w=4  l=0.35
Cw_route_14_4  vw_route_14_4  vss  200f
R_bleed_14_4  vw_route_14_4  vss  10000meg
XMN4_r_14_4  vw_route_14_4  we_route  iwrite_route_14_4  vss  sky130_fd_pr__nfet_01v8  w=0.5  l=0.5
X_rhebb_14_4  iwrite_route_14_4  inp_upper_4  ierr_dig_14  vcm_route  vdd vss  hebbian_mult
XMPRED_r_14_5  i_pred_14  vw_route_14_5  vss  vss  sky130_fd_pr__nfet_01v8  w=4  l=0.35
Cw_route_14_5  vw_route_14_5  vss  200f
R_bleed_14_5  vw_route_14_5  vss  10000meg
XMN4_r_14_5  vw_route_14_5  we_route  iwrite_route_14_5  vss  sky130_fd_pr__nfet_01v8  w=0.5  l=0.5
X_rhebb_14_5  iwrite_route_14_5  inp_upper_5  ierr_dig_14  vcm_route  vdd vss  hebbian_mult
XMPRED_r_14_6  i_pred_14  vw_route_14_6  vss  vss  sky130_fd_pr__nfet_01v8  w=4  l=0.35
Cw_route_14_6  vw_route_14_6  vss  200f
R_bleed_14_6  vw_route_14_6  vss  10000meg
XMN4_r_14_6  vw_route_14_6  we_route  iwrite_route_14_6  vss  sky130_fd_pr__nfet_01v8  w=0.5  l=0.5
X_rhebb_14_6  iwrite_route_14_6  inp_upper_6  ierr_dig_14  vcm_route  vdd vss  hebbian_mult
XMPRED_r_14_7  i_pred_14  vw_route_14_7  vss  vss  sky130_fd_pr__nfet_01v8  w=4  l=0.35
Cw_route_14_7  vw_route_14_7  vss  200f
R_bleed_14_7  vw_route_14_7  vss  10000meg
XMN4_r_14_7  vw_route_14_7  we_route  iwrite_route_14_7  vss  sky130_fd_pr__nfet_01v8  w=0.5  l=0.5
X_rhebb_14_7  iwrite_route_14_7  inp_upper_7  ierr_dig_14  vcm_route  vdd vss  hebbian_mult
XMPRED_r_14_8  i_pred_14  vw_route_14_8  vss  vss  sky130_fd_pr__nfet_01v8  w=4  l=0.35
Cw_route_14_8  vw_route_14_8  vss  200f
R_bleed_14_8  vw_route_14_8  vss  10000meg
XMN4_r_14_8  vw_route_14_8  we_route  iwrite_route_14_8  vss  sky130_fd_pr__nfet_01v8  w=0.5  l=0.5
X_rhebb_14_8  iwrite_route_14_8  inp_upper_8  ierr_dig_14  vcm_route  vdd vss  hebbian_mult
XMPRED_r_14_9  i_pred_14  vw_route_14_9  vss  vss  sky130_fd_pr__nfet_01v8  w=4  l=0.35
Cw_route_14_9  vw_route_14_9  vss  200f
R_bleed_14_9  vw_route_14_9  vss  10000meg
XMN4_r_14_9  vw_route_14_9  we_route  iwrite_route_14_9  vss  sky130_fd_pr__nfet_01v8  w=0.5  l=0.5
X_rhebb_14_9  iwrite_route_14_9  inp_upper_9  ierr_dig_14  vcm_route  vdd vss  hebbian_mult
XMPRED_r_14_10  i_pred_14  vw_route_14_10  vss  vss  sky130_fd_pr__nfet_01v8  w=4  l=0.35
Cw_route_14_10  vw_route_14_10  vss  200f
R_bleed_14_10  vw_route_14_10  vss  10000meg
XMN4_r_14_10  vw_route_14_10  we_route  iwrite_route_14_10  vss  sky130_fd_pr__nfet_01v8  w=0.5  l=0.5
X_rhebb_14_10  iwrite_route_14_10  inp_upper_10  ierr_dig_14  vcm_route  vdd vss  hebbian_mult
XMPRED_r_14_11  i_pred_14  vw_route_14_11  vss  vss  sky130_fd_pr__nfet_01v8  w=4  l=0.35
Cw_route_14_11  vw_route_14_11  vss  200f
R_bleed_14_11  vw_route_14_11  vss  10000meg
XMN4_r_14_11  vw_route_14_11  we_route  iwrite_route_14_11  vss  sky130_fd_pr__nfet_01v8  w=0.5  l=0.5
X_rhebb_14_11  iwrite_route_14_11  inp_upper_11  ierr_dig_14  vcm_route  vdd vss  hebbian_mult
XMPRED_r_14_12  i_pred_14  vw_route_14_12  vss  vss  sky130_fd_pr__nfet_01v8  w=4  l=0.35
Cw_route_14_12  vw_route_14_12  vss  200f
R_bleed_14_12  vw_route_14_12  vss  10000meg
XMN4_r_14_12  vw_route_14_12  we_route  iwrite_route_14_12  vss  sky130_fd_pr__nfet_01v8  w=0.5  l=0.5
X_rhebb_14_12  iwrite_route_14_12  inp_upper_12  ierr_dig_14  vcm_route  vdd vss  hebbian_mult
XMPRED_r_14_13  i_pred_14  vw_route_14_13  vss  vss  sky130_fd_pr__nfet_01v8  w=4  l=0.35
Cw_route_14_13  vw_route_14_13  vss  200f
R_bleed_14_13  vw_route_14_13  vss  10000meg
XMN4_r_14_13  vw_route_14_13  we_route  iwrite_route_14_13  vss  sky130_fd_pr__nfet_01v8  w=0.5  l=0.5
X_rhebb_14_13  iwrite_route_14_13  inp_upper_13  ierr_dig_14  vcm_route  vdd vss  hebbian_mult
XMPRED_r_14_14  i_pred_14  vw_route_14_14  vss  vss  sky130_fd_pr__nfet_01v8  w=4  l=0.35
Cw_route_14_14  vw_route_14_14  vss  200f
R_bleed_14_14  vw_route_14_14  vss  10000meg
XMN4_r_14_14  vw_route_14_14  we_route  iwrite_route_14_14  vss  sky130_fd_pr__nfet_01v8  w=0.5  l=0.5
X_rhebb_14_14  iwrite_route_14_14  inp_upper_14  ierr_dig_14  vcm_route  vdd vss  hebbian_mult
XMPRED_r_14_15  i_pred_14  vw_route_14_15  vss  vss  sky130_fd_pr__nfet_01v8  w=4  l=0.35
Cw_route_14_15  vw_route_14_15  vss  200f
R_bleed_14_15  vw_route_14_15  vss  10000meg
XMN4_r_14_15  vw_route_14_15  we_route  iwrite_route_14_15  vss  sky130_fd_pr__nfet_01v8  w=0.5  l=0.5
X_rhebb_14_15  iwrite_route_14_15  inp_upper_15  ierr_dig_14  vcm_route  vdd vss  hebbian_mult
XMPRED_r_14_16  i_pred_14  vw_route_14_16  vss  vss  sky130_fd_pr__nfet_01v8  w=4  l=0.35
Cw_route_14_16  vw_route_14_16  vss  200f
R_bleed_14_16  vw_route_14_16  vss  10000meg
XMN4_r_14_16  vw_route_14_16  we_route  iwrite_route_14_16  vss  sky130_fd_pr__nfet_01v8  w=0.5  l=0.5
X_rhebb_14_16  iwrite_route_14_16  inp_upper_16  ierr_dig_14  vcm_route  vdd vss  hebbian_mult
XMPRED_r_14_17  i_pred_14  vw_route_14_17  vss  vss  sky130_fd_pr__nfet_01v8  w=4  l=0.35
Cw_route_14_17  vw_route_14_17  vss  200f
R_bleed_14_17  vw_route_14_17  vss  10000meg
XMN4_r_14_17  vw_route_14_17  we_route  iwrite_route_14_17  vss  sky130_fd_pr__nfet_01v8  w=0.5  l=0.5
X_rhebb_14_17  iwrite_route_14_17  inp_upper_17  ierr_dig_14  vcm_route  vdd vss  hebbian_mult
XMPRED_r_14_18  i_pred_14  vw_route_14_18  vss  vss  sky130_fd_pr__nfet_01v8  w=4  l=0.35
Cw_route_14_18  vw_route_14_18  vss  200f
R_bleed_14_18  vw_route_14_18  vss  10000meg
XMN4_r_14_18  vw_route_14_18  we_route  iwrite_route_14_18  vss  sky130_fd_pr__nfet_01v8  w=0.5  l=0.5
X_rhebb_14_18  iwrite_route_14_18  inp_upper_18  ierr_dig_14  vcm_route  vdd vss  hebbian_mult
XMPRED_r_14_19  i_pred_14  vw_route_14_19  vss  vss  sky130_fd_pr__nfet_01v8  w=4  l=0.35
Cw_route_14_19  vw_route_14_19  vss  200f
R_bleed_14_19  vw_route_14_19  vss  10000meg
XMN4_r_14_19  vw_route_14_19  we_route  iwrite_route_14_19  vss  sky130_fd_pr__nfet_01v8  w=0.5  l=0.5
X_rhebb_14_19  iwrite_route_14_19  inp_upper_19  ierr_dig_14  vcm_route  vdd vss  hebbian_mult
XMPRED_r_14_20  i_pred_14  vw_route_14_20  vss  vss  sky130_fd_pr__nfet_01v8  w=4  l=0.35
Cw_route_14_20  vw_route_14_20  vss  200f
R_bleed_14_20  vw_route_14_20  vss  10000meg
XMN4_r_14_20  vw_route_14_20  we_route  iwrite_route_14_20  vss  sky130_fd_pr__nfet_01v8  w=0.5  l=0.5
X_rhebb_14_20  iwrite_route_14_20  inp_upper_20  ierr_dig_14  vcm_route  vdd vss  hebbian_mult
XMPRED_r_14_21  i_pred_14  vw_route_14_21  vss  vss  sky130_fd_pr__nfet_01v8  w=4  l=0.35
Cw_route_14_21  vw_route_14_21  vss  200f
R_bleed_14_21  vw_route_14_21  vss  10000meg
XMN4_r_14_21  vw_route_14_21  we_route  iwrite_route_14_21  vss  sky130_fd_pr__nfet_01v8  w=0.5  l=0.5
X_rhebb_14_21  iwrite_route_14_21  inp_upper_21  ierr_dig_14  vcm_route  vdd vss  hebbian_mult
XMPRED_r_14_22  i_pred_14  vw_route_14_22  vss  vss  sky130_fd_pr__nfet_01v8  w=4  l=0.35
Cw_route_14_22  vw_route_14_22  vss  200f
R_bleed_14_22  vw_route_14_22  vss  10000meg
XMN4_r_14_22  vw_route_14_22  we_route  iwrite_route_14_22  vss  sky130_fd_pr__nfet_01v8  w=0.5  l=0.5
X_rhebb_14_22  iwrite_route_14_22  inp_upper_22  ierr_dig_14  vcm_route  vdd vss  hebbian_mult
XMPRED_r_14_23  i_pred_14  vw_route_14_23  vss  vss  sky130_fd_pr__nfet_01v8  w=4  l=0.35
Cw_route_14_23  vw_route_14_23  vss  200f
R_bleed_14_23  vw_route_14_23  vss  10000meg
XMN4_r_14_23  vw_route_14_23  we_route  iwrite_route_14_23  vss  sky130_fd_pr__nfet_01v8  w=0.5  l=0.5
X_rhebb_14_23  iwrite_route_14_23  inp_upper_23  ierr_dig_14  vcm_route  vdd vss  hebbian_mult
XMPRED_r_14_24  i_pred_14  vw_route_14_24  vss  vss  sky130_fd_pr__nfet_01v8  w=4  l=0.35
Cw_route_14_24  vw_route_14_24  vss  200f
R_bleed_14_24  vw_route_14_24  vss  10000meg
XMN4_r_14_24  vw_route_14_24  we_route  iwrite_route_14_24  vss  sky130_fd_pr__nfet_01v8  w=0.5  l=0.5
X_rhebb_14_24  iwrite_route_14_24  inp_upper_24  ierr_dig_14  vcm_route  vdd vss  hebbian_mult
XMPRED_r_14_25  i_pred_14  vw_route_14_25  vss  vss  sky130_fd_pr__nfet_01v8  w=4  l=0.35
Cw_route_14_25  vw_route_14_25  vss  200f
R_bleed_14_25  vw_route_14_25  vss  10000meg
XMN4_r_14_25  vw_route_14_25  we_route  iwrite_route_14_25  vss  sky130_fd_pr__nfet_01v8  w=0.5  l=0.5
X_rhebb_14_25  iwrite_route_14_25  inp_upper_25  ierr_dig_14  vcm_route  vdd vss  hebbian_mult
XMPRED_r_14_26  i_pred_14  vw_route_14_26  vss  vss  sky130_fd_pr__nfet_01v8  w=4  l=0.35
Cw_route_14_26  vw_route_14_26  vss  200f
R_bleed_14_26  vw_route_14_26  vss  10000meg
XMN4_r_14_26  vw_route_14_26  we_route  iwrite_route_14_26  vss  sky130_fd_pr__nfet_01v8  w=0.5  l=0.5
X_rhebb_14_26  iwrite_route_14_26  inp_upper_26  ierr_dig_14  vcm_route  vdd vss  hebbian_mult
XMPRED_r_14_27  i_pred_14  vw_route_14_27  vss  vss  sky130_fd_pr__nfet_01v8  w=4  l=0.35
Cw_route_14_27  vw_route_14_27  vss  200f
R_bleed_14_27  vw_route_14_27  vss  10000meg
XMN4_r_14_27  vw_route_14_27  we_route  iwrite_route_14_27  vss  sky130_fd_pr__nfet_01v8  w=0.5  l=0.5
X_rhebb_14_27  iwrite_route_14_27  inp_upper_27  ierr_dig_14  vcm_route  vdd vss  hebbian_mult
XMPRED_r_14_28  i_pred_14  vw_route_14_28  vss  vss  sky130_fd_pr__nfet_01v8  w=4  l=0.35
Cw_route_14_28  vw_route_14_28  vss  200f
R_bleed_14_28  vw_route_14_28  vss  10000meg
XMN4_r_14_28  vw_route_14_28  we_route  iwrite_route_14_28  vss  sky130_fd_pr__nfet_01v8  w=0.5  l=0.5
X_rhebb_14_28  iwrite_route_14_28  inp_upper_28  ierr_dig_14  vcm_route  vdd vss  hebbian_mult
XMPRED_r_14_29  i_pred_14  vw_route_14_29  vss  vss  sky130_fd_pr__nfet_01v8  w=4  l=0.35
Cw_route_14_29  vw_route_14_29  vss  200f
R_bleed_14_29  vw_route_14_29  vss  10000meg
XMN4_r_14_29  vw_route_14_29  we_route  iwrite_route_14_29  vss  sky130_fd_pr__nfet_01v8  w=0.5  l=0.5
X_rhebb_14_29  iwrite_route_14_29  inp_upper_29  ierr_dig_14  vcm_route  vdd vss  hebbian_mult
XMPRED_r_14_30  i_pred_14  vw_route_14_30  vss  vss  sky130_fd_pr__nfet_01v8  w=4  l=0.35
Cw_route_14_30  vw_route_14_30  vss  200f
R_bleed_14_30  vw_route_14_30  vss  10000meg
XMN4_r_14_30  vw_route_14_30  we_route  iwrite_route_14_30  vss  sky130_fd_pr__nfet_01v8  w=0.5  l=0.5
X_rhebb_14_30  iwrite_route_14_30  inp_upper_30  ierr_dig_14  vcm_route  vdd vss  hebbian_mult
XMPRED_r_14_31  i_pred_14  vw_route_14_31  vss  vss  sky130_fd_pr__nfet_01v8  w=4  l=0.35
Cw_route_14_31  vw_route_14_31  vss  200f
R_bleed_14_31  vw_route_14_31  vss  10000meg
XMN4_r_14_31  vw_route_14_31  we_route  iwrite_route_14_31  vss  sky130_fd_pr__nfet_01v8  w=0.5  l=0.5
X_rhebb_14_31  iwrite_route_14_31  inp_upper_31  ierr_dig_14  vcm_route  vdd vss  hebbian_mult

* ── Destination row 15 ── 32 source connections ──────────────────────────
XMPRED_r_15_0  i_pred_15  vw_route_15_0  vss  vss  sky130_fd_pr__nfet_01v8  w=4  l=0.35
Cw_route_15_0  vw_route_15_0  vss  200f
R_bleed_15_0  vw_route_15_0  vss  10000meg
XMN4_r_15_0  vw_route_15_0  we_route  iwrite_route_15_0  vss  sky130_fd_pr__nfet_01v8  w=0.5  l=0.5
X_rhebb_15_0  iwrite_route_15_0  inp_upper_0  ierr_dig_15  vcm_route  vdd vss  hebbian_mult
XMPRED_r_15_1  i_pred_15  vw_route_15_1  vss  vss  sky130_fd_pr__nfet_01v8  w=4  l=0.35
Cw_route_15_1  vw_route_15_1  vss  200f
R_bleed_15_1  vw_route_15_1  vss  10000meg
XMN4_r_15_1  vw_route_15_1  we_route  iwrite_route_15_1  vss  sky130_fd_pr__nfet_01v8  w=0.5  l=0.5
X_rhebb_15_1  iwrite_route_15_1  inp_upper_1  ierr_dig_15  vcm_route  vdd vss  hebbian_mult
XMPRED_r_15_2  i_pred_15  vw_route_15_2  vss  vss  sky130_fd_pr__nfet_01v8  w=4  l=0.35
Cw_route_15_2  vw_route_15_2  vss  200f
R_bleed_15_2  vw_route_15_2  vss  10000meg
XMN4_r_15_2  vw_route_15_2  we_route  iwrite_route_15_2  vss  sky130_fd_pr__nfet_01v8  w=0.5  l=0.5
X_rhebb_15_2  iwrite_route_15_2  inp_upper_2  ierr_dig_15  vcm_route  vdd vss  hebbian_mult
XMPRED_r_15_3  i_pred_15  vw_route_15_3  vss  vss  sky130_fd_pr__nfet_01v8  w=4  l=0.35
Cw_route_15_3  vw_route_15_3  vss  200f
R_bleed_15_3  vw_route_15_3  vss  10000meg
XMN4_r_15_3  vw_route_15_3  we_route  iwrite_route_15_3  vss  sky130_fd_pr__nfet_01v8  w=0.5  l=0.5
X_rhebb_15_3  iwrite_route_15_3  inp_upper_3  ierr_dig_15  vcm_route  vdd vss  hebbian_mult
XMPRED_r_15_4  i_pred_15  vw_route_15_4  vss  vss  sky130_fd_pr__nfet_01v8  w=4  l=0.35
Cw_route_15_4  vw_route_15_4  vss  200f
R_bleed_15_4  vw_route_15_4  vss  10000meg
XMN4_r_15_4  vw_route_15_4  we_route  iwrite_route_15_4  vss  sky130_fd_pr__nfet_01v8  w=0.5  l=0.5
X_rhebb_15_4  iwrite_route_15_4  inp_upper_4  ierr_dig_15  vcm_route  vdd vss  hebbian_mult
XMPRED_r_15_5  i_pred_15  vw_route_15_5  vss  vss  sky130_fd_pr__nfet_01v8  w=4  l=0.35
Cw_route_15_5  vw_route_15_5  vss  200f
R_bleed_15_5  vw_route_15_5  vss  10000meg
XMN4_r_15_5  vw_route_15_5  we_route  iwrite_route_15_5  vss  sky130_fd_pr__nfet_01v8  w=0.5  l=0.5
X_rhebb_15_5  iwrite_route_15_5  inp_upper_5  ierr_dig_15  vcm_route  vdd vss  hebbian_mult
XMPRED_r_15_6  i_pred_15  vw_route_15_6  vss  vss  sky130_fd_pr__nfet_01v8  w=4  l=0.35
Cw_route_15_6  vw_route_15_6  vss  200f
R_bleed_15_6  vw_route_15_6  vss  10000meg
XMN4_r_15_6  vw_route_15_6  we_route  iwrite_route_15_6  vss  sky130_fd_pr__nfet_01v8  w=0.5  l=0.5
X_rhebb_15_6  iwrite_route_15_6  inp_upper_6  ierr_dig_15  vcm_route  vdd vss  hebbian_mult
XMPRED_r_15_7  i_pred_15  vw_route_15_7  vss  vss  sky130_fd_pr__nfet_01v8  w=4  l=0.35
Cw_route_15_7  vw_route_15_7  vss  200f
R_bleed_15_7  vw_route_15_7  vss  10000meg
XMN4_r_15_7  vw_route_15_7  we_route  iwrite_route_15_7  vss  sky130_fd_pr__nfet_01v8  w=0.5  l=0.5
X_rhebb_15_7  iwrite_route_15_7  inp_upper_7  ierr_dig_15  vcm_route  vdd vss  hebbian_mult
XMPRED_r_15_8  i_pred_15  vw_route_15_8  vss  vss  sky130_fd_pr__nfet_01v8  w=4  l=0.35
Cw_route_15_8  vw_route_15_8  vss  200f
R_bleed_15_8  vw_route_15_8  vss  10000meg
XMN4_r_15_8  vw_route_15_8  we_route  iwrite_route_15_8  vss  sky130_fd_pr__nfet_01v8  w=0.5  l=0.5
X_rhebb_15_8  iwrite_route_15_8  inp_upper_8  ierr_dig_15  vcm_route  vdd vss  hebbian_mult
XMPRED_r_15_9  i_pred_15  vw_route_15_9  vss  vss  sky130_fd_pr__nfet_01v8  w=4  l=0.35
Cw_route_15_9  vw_route_15_9  vss  200f
R_bleed_15_9  vw_route_15_9  vss  10000meg
XMN4_r_15_9  vw_route_15_9  we_route  iwrite_route_15_9  vss  sky130_fd_pr__nfet_01v8  w=0.5  l=0.5
X_rhebb_15_9  iwrite_route_15_9  inp_upper_9  ierr_dig_15  vcm_route  vdd vss  hebbian_mult
XMPRED_r_15_10  i_pred_15  vw_route_15_10  vss  vss  sky130_fd_pr__nfet_01v8  w=4  l=0.35
Cw_route_15_10  vw_route_15_10  vss  200f
R_bleed_15_10  vw_route_15_10  vss  10000meg
XMN4_r_15_10  vw_route_15_10  we_route  iwrite_route_15_10  vss  sky130_fd_pr__nfet_01v8  w=0.5  l=0.5
X_rhebb_15_10  iwrite_route_15_10  inp_upper_10  ierr_dig_15  vcm_route  vdd vss  hebbian_mult
XMPRED_r_15_11  i_pred_15  vw_route_15_11  vss  vss  sky130_fd_pr__nfet_01v8  w=4  l=0.35
Cw_route_15_11  vw_route_15_11  vss  200f
R_bleed_15_11  vw_route_15_11  vss  10000meg
XMN4_r_15_11  vw_route_15_11  we_route  iwrite_route_15_11  vss  sky130_fd_pr__nfet_01v8  w=0.5  l=0.5
X_rhebb_15_11  iwrite_route_15_11  inp_upper_11  ierr_dig_15  vcm_route  vdd vss  hebbian_mult
XMPRED_r_15_12  i_pred_15  vw_route_15_12  vss  vss  sky130_fd_pr__nfet_01v8  w=4  l=0.35
Cw_route_15_12  vw_route_15_12  vss  200f
R_bleed_15_12  vw_route_15_12  vss  10000meg
XMN4_r_15_12  vw_route_15_12  we_route  iwrite_route_15_12  vss  sky130_fd_pr__nfet_01v8  w=0.5  l=0.5
X_rhebb_15_12  iwrite_route_15_12  inp_upper_12  ierr_dig_15  vcm_route  vdd vss  hebbian_mult
XMPRED_r_15_13  i_pred_15  vw_route_15_13  vss  vss  sky130_fd_pr__nfet_01v8  w=4  l=0.35
Cw_route_15_13  vw_route_15_13  vss  200f
R_bleed_15_13  vw_route_15_13  vss  10000meg
XMN4_r_15_13  vw_route_15_13  we_route  iwrite_route_15_13  vss  sky130_fd_pr__nfet_01v8  w=0.5  l=0.5
X_rhebb_15_13  iwrite_route_15_13  inp_upper_13  ierr_dig_15  vcm_route  vdd vss  hebbian_mult
XMPRED_r_15_14  i_pred_15  vw_route_15_14  vss  vss  sky130_fd_pr__nfet_01v8  w=4  l=0.35
Cw_route_15_14  vw_route_15_14  vss  200f
R_bleed_15_14  vw_route_15_14  vss  10000meg
XMN4_r_15_14  vw_route_15_14  we_route  iwrite_route_15_14  vss  sky130_fd_pr__nfet_01v8  w=0.5  l=0.5
X_rhebb_15_14  iwrite_route_15_14  inp_upper_14  ierr_dig_15  vcm_route  vdd vss  hebbian_mult
XMPRED_r_15_15  i_pred_15  vw_route_15_15  vss  vss  sky130_fd_pr__nfet_01v8  w=4  l=0.35
Cw_route_15_15  vw_route_15_15  vss  200f
R_bleed_15_15  vw_route_15_15  vss  10000meg
XMN4_r_15_15  vw_route_15_15  we_route  iwrite_route_15_15  vss  sky130_fd_pr__nfet_01v8  w=0.5  l=0.5
X_rhebb_15_15  iwrite_route_15_15  inp_upper_15  ierr_dig_15  vcm_route  vdd vss  hebbian_mult
XMPRED_r_15_16  i_pred_15  vw_route_15_16  vss  vss  sky130_fd_pr__nfet_01v8  w=4  l=0.35
Cw_route_15_16  vw_route_15_16  vss  200f
R_bleed_15_16  vw_route_15_16  vss  10000meg
XMN4_r_15_16  vw_route_15_16  we_route  iwrite_route_15_16  vss  sky130_fd_pr__nfet_01v8  w=0.5  l=0.5
X_rhebb_15_16  iwrite_route_15_16  inp_upper_16  ierr_dig_15  vcm_route  vdd vss  hebbian_mult
XMPRED_r_15_17  i_pred_15  vw_route_15_17  vss  vss  sky130_fd_pr__nfet_01v8  w=4  l=0.35
Cw_route_15_17  vw_route_15_17  vss  200f
R_bleed_15_17  vw_route_15_17  vss  10000meg
XMN4_r_15_17  vw_route_15_17  we_route  iwrite_route_15_17  vss  sky130_fd_pr__nfet_01v8  w=0.5  l=0.5
X_rhebb_15_17  iwrite_route_15_17  inp_upper_17  ierr_dig_15  vcm_route  vdd vss  hebbian_mult
XMPRED_r_15_18  i_pred_15  vw_route_15_18  vss  vss  sky130_fd_pr__nfet_01v8  w=4  l=0.35
Cw_route_15_18  vw_route_15_18  vss  200f
R_bleed_15_18  vw_route_15_18  vss  10000meg
XMN4_r_15_18  vw_route_15_18  we_route  iwrite_route_15_18  vss  sky130_fd_pr__nfet_01v8  w=0.5  l=0.5
X_rhebb_15_18  iwrite_route_15_18  inp_upper_18  ierr_dig_15  vcm_route  vdd vss  hebbian_mult
XMPRED_r_15_19  i_pred_15  vw_route_15_19  vss  vss  sky130_fd_pr__nfet_01v8  w=4  l=0.35
Cw_route_15_19  vw_route_15_19  vss  200f
R_bleed_15_19  vw_route_15_19  vss  10000meg
XMN4_r_15_19  vw_route_15_19  we_route  iwrite_route_15_19  vss  sky130_fd_pr__nfet_01v8  w=0.5  l=0.5
X_rhebb_15_19  iwrite_route_15_19  inp_upper_19  ierr_dig_15  vcm_route  vdd vss  hebbian_mult
XMPRED_r_15_20  i_pred_15  vw_route_15_20  vss  vss  sky130_fd_pr__nfet_01v8  w=4  l=0.35
Cw_route_15_20  vw_route_15_20  vss  200f
R_bleed_15_20  vw_route_15_20  vss  10000meg
XMN4_r_15_20  vw_route_15_20  we_route  iwrite_route_15_20  vss  sky130_fd_pr__nfet_01v8  w=0.5  l=0.5
X_rhebb_15_20  iwrite_route_15_20  inp_upper_20  ierr_dig_15  vcm_route  vdd vss  hebbian_mult
XMPRED_r_15_21  i_pred_15  vw_route_15_21  vss  vss  sky130_fd_pr__nfet_01v8  w=4  l=0.35
Cw_route_15_21  vw_route_15_21  vss  200f
R_bleed_15_21  vw_route_15_21  vss  10000meg
XMN4_r_15_21  vw_route_15_21  we_route  iwrite_route_15_21  vss  sky130_fd_pr__nfet_01v8  w=0.5  l=0.5
X_rhebb_15_21  iwrite_route_15_21  inp_upper_21  ierr_dig_15  vcm_route  vdd vss  hebbian_mult
XMPRED_r_15_22  i_pred_15  vw_route_15_22  vss  vss  sky130_fd_pr__nfet_01v8  w=4  l=0.35
Cw_route_15_22  vw_route_15_22  vss  200f
R_bleed_15_22  vw_route_15_22  vss  10000meg
XMN4_r_15_22  vw_route_15_22  we_route  iwrite_route_15_22  vss  sky130_fd_pr__nfet_01v8  w=0.5  l=0.5
X_rhebb_15_22  iwrite_route_15_22  inp_upper_22  ierr_dig_15  vcm_route  vdd vss  hebbian_mult
XMPRED_r_15_23  i_pred_15  vw_route_15_23  vss  vss  sky130_fd_pr__nfet_01v8  w=4  l=0.35
Cw_route_15_23  vw_route_15_23  vss  200f
R_bleed_15_23  vw_route_15_23  vss  10000meg
XMN4_r_15_23  vw_route_15_23  we_route  iwrite_route_15_23  vss  sky130_fd_pr__nfet_01v8  w=0.5  l=0.5
X_rhebb_15_23  iwrite_route_15_23  inp_upper_23  ierr_dig_15  vcm_route  vdd vss  hebbian_mult
XMPRED_r_15_24  i_pred_15  vw_route_15_24  vss  vss  sky130_fd_pr__nfet_01v8  w=4  l=0.35
Cw_route_15_24  vw_route_15_24  vss  200f
R_bleed_15_24  vw_route_15_24  vss  10000meg
XMN4_r_15_24  vw_route_15_24  we_route  iwrite_route_15_24  vss  sky130_fd_pr__nfet_01v8  w=0.5  l=0.5
X_rhebb_15_24  iwrite_route_15_24  inp_upper_24  ierr_dig_15  vcm_route  vdd vss  hebbian_mult
XMPRED_r_15_25  i_pred_15  vw_route_15_25  vss  vss  sky130_fd_pr__nfet_01v8  w=4  l=0.35
Cw_route_15_25  vw_route_15_25  vss  200f
R_bleed_15_25  vw_route_15_25  vss  10000meg
XMN4_r_15_25  vw_route_15_25  we_route  iwrite_route_15_25  vss  sky130_fd_pr__nfet_01v8  w=0.5  l=0.5
X_rhebb_15_25  iwrite_route_15_25  inp_upper_25  ierr_dig_15  vcm_route  vdd vss  hebbian_mult
XMPRED_r_15_26  i_pred_15  vw_route_15_26  vss  vss  sky130_fd_pr__nfet_01v8  w=4  l=0.35
Cw_route_15_26  vw_route_15_26  vss  200f
R_bleed_15_26  vw_route_15_26  vss  10000meg
XMN4_r_15_26  vw_route_15_26  we_route  iwrite_route_15_26  vss  sky130_fd_pr__nfet_01v8  w=0.5  l=0.5
X_rhebb_15_26  iwrite_route_15_26  inp_upper_26  ierr_dig_15  vcm_route  vdd vss  hebbian_mult
XMPRED_r_15_27  i_pred_15  vw_route_15_27  vss  vss  sky130_fd_pr__nfet_01v8  w=4  l=0.35
Cw_route_15_27  vw_route_15_27  vss  200f
R_bleed_15_27  vw_route_15_27  vss  10000meg
XMN4_r_15_27  vw_route_15_27  we_route  iwrite_route_15_27  vss  sky130_fd_pr__nfet_01v8  w=0.5  l=0.5
X_rhebb_15_27  iwrite_route_15_27  inp_upper_27  ierr_dig_15  vcm_route  vdd vss  hebbian_mult
XMPRED_r_15_28  i_pred_15  vw_route_15_28  vss  vss  sky130_fd_pr__nfet_01v8  w=4  l=0.35
Cw_route_15_28  vw_route_15_28  vss  200f
R_bleed_15_28  vw_route_15_28  vss  10000meg
XMN4_r_15_28  vw_route_15_28  we_route  iwrite_route_15_28  vss  sky130_fd_pr__nfet_01v8  w=0.5  l=0.5
X_rhebb_15_28  iwrite_route_15_28  inp_upper_28  ierr_dig_15  vcm_route  vdd vss  hebbian_mult
XMPRED_r_15_29  i_pred_15  vw_route_15_29  vss  vss  sky130_fd_pr__nfet_01v8  w=4  l=0.35
Cw_route_15_29  vw_route_15_29  vss  200f
R_bleed_15_29  vw_route_15_29  vss  10000meg
XMN4_r_15_29  vw_route_15_29  we_route  iwrite_route_15_29  vss  sky130_fd_pr__nfet_01v8  w=0.5  l=0.5
X_rhebb_15_29  iwrite_route_15_29  inp_upper_29  ierr_dig_15  vcm_route  vdd vss  hebbian_mult
XMPRED_r_15_30  i_pred_15  vw_route_15_30  vss  vss  sky130_fd_pr__nfet_01v8  w=4  l=0.35
Cw_route_15_30  vw_route_15_30  vss  200f
R_bleed_15_30  vw_route_15_30  vss  10000meg
XMN4_r_15_30  vw_route_15_30  we_route  iwrite_route_15_30  vss  sky130_fd_pr__nfet_01v8  w=0.5  l=0.5
X_rhebb_15_30  iwrite_route_15_30  inp_upper_30  ierr_dig_15  vcm_route  vdd vss  hebbian_mult
XMPRED_r_15_31  i_pred_15  vw_route_15_31  vss  vss  sky130_fd_pr__nfet_01v8  w=4  l=0.35
Cw_route_15_31  vw_route_15_31  vss  200f
R_bleed_15_31  vw_route_15_31  vss  10000meg
XMN4_r_15_31  vw_route_15_31  we_route  iwrite_route_15_31  vss  sky130_fd_pr__nfet_01v8  w=0.5  l=0.5
X_rhebb_15_31  iwrite_route_15_31  inp_upper_31  ierr_dig_15  vcm_route  vdd vss  hebbian_mult

* ── Destination row 16 ── 32 source connections ──────────────────────────
XMPRED_r_16_0  i_pred_16  vw_route_16_0  vss  vss  sky130_fd_pr__nfet_01v8  w=4  l=0.35
Cw_route_16_0  vw_route_16_0  vss  200f
R_bleed_16_0  vw_route_16_0  vss  10000meg
XMN4_r_16_0  vw_route_16_0  we_route  iwrite_route_16_0  vss  sky130_fd_pr__nfet_01v8  w=0.5  l=0.5
X_rhebb_16_0  iwrite_route_16_0  inp_upper_0  ierr_dig_16  vcm_route  vdd vss  hebbian_mult
XMPRED_r_16_1  i_pred_16  vw_route_16_1  vss  vss  sky130_fd_pr__nfet_01v8  w=4  l=0.35
Cw_route_16_1  vw_route_16_1  vss  200f
R_bleed_16_1  vw_route_16_1  vss  10000meg
XMN4_r_16_1  vw_route_16_1  we_route  iwrite_route_16_1  vss  sky130_fd_pr__nfet_01v8  w=0.5  l=0.5
X_rhebb_16_1  iwrite_route_16_1  inp_upper_1  ierr_dig_16  vcm_route  vdd vss  hebbian_mult
XMPRED_r_16_2  i_pred_16  vw_route_16_2  vss  vss  sky130_fd_pr__nfet_01v8  w=4  l=0.35
Cw_route_16_2  vw_route_16_2  vss  200f
R_bleed_16_2  vw_route_16_2  vss  10000meg
XMN4_r_16_2  vw_route_16_2  we_route  iwrite_route_16_2  vss  sky130_fd_pr__nfet_01v8  w=0.5  l=0.5
X_rhebb_16_2  iwrite_route_16_2  inp_upper_2  ierr_dig_16  vcm_route  vdd vss  hebbian_mult
XMPRED_r_16_3  i_pred_16  vw_route_16_3  vss  vss  sky130_fd_pr__nfet_01v8  w=4  l=0.35
Cw_route_16_3  vw_route_16_3  vss  200f
R_bleed_16_3  vw_route_16_3  vss  10000meg
XMN4_r_16_3  vw_route_16_3  we_route  iwrite_route_16_3  vss  sky130_fd_pr__nfet_01v8  w=0.5  l=0.5
X_rhebb_16_3  iwrite_route_16_3  inp_upper_3  ierr_dig_16  vcm_route  vdd vss  hebbian_mult
XMPRED_r_16_4  i_pred_16  vw_route_16_4  vss  vss  sky130_fd_pr__nfet_01v8  w=4  l=0.35
Cw_route_16_4  vw_route_16_4  vss  200f
R_bleed_16_4  vw_route_16_4  vss  10000meg
XMN4_r_16_4  vw_route_16_4  we_route  iwrite_route_16_4  vss  sky130_fd_pr__nfet_01v8  w=0.5  l=0.5
X_rhebb_16_4  iwrite_route_16_4  inp_upper_4  ierr_dig_16  vcm_route  vdd vss  hebbian_mult
XMPRED_r_16_5  i_pred_16  vw_route_16_5  vss  vss  sky130_fd_pr__nfet_01v8  w=4  l=0.35
Cw_route_16_5  vw_route_16_5  vss  200f
R_bleed_16_5  vw_route_16_5  vss  10000meg
XMN4_r_16_5  vw_route_16_5  we_route  iwrite_route_16_5  vss  sky130_fd_pr__nfet_01v8  w=0.5  l=0.5
X_rhebb_16_5  iwrite_route_16_5  inp_upper_5  ierr_dig_16  vcm_route  vdd vss  hebbian_mult
XMPRED_r_16_6  i_pred_16  vw_route_16_6  vss  vss  sky130_fd_pr__nfet_01v8  w=4  l=0.35
Cw_route_16_6  vw_route_16_6  vss  200f
R_bleed_16_6  vw_route_16_6  vss  10000meg
XMN4_r_16_6  vw_route_16_6  we_route  iwrite_route_16_6  vss  sky130_fd_pr__nfet_01v8  w=0.5  l=0.5
X_rhebb_16_6  iwrite_route_16_6  inp_upper_6  ierr_dig_16  vcm_route  vdd vss  hebbian_mult
XMPRED_r_16_7  i_pred_16  vw_route_16_7  vss  vss  sky130_fd_pr__nfet_01v8  w=4  l=0.35
Cw_route_16_7  vw_route_16_7  vss  200f
R_bleed_16_7  vw_route_16_7  vss  10000meg
XMN4_r_16_7  vw_route_16_7  we_route  iwrite_route_16_7  vss  sky130_fd_pr__nfet_01v8  w=0.5  l=0.5
X_rhebb_16_7  iwrite_route_16_7  inp_upper_7  ierr_dig_16  vcm_route  vdd vss  hebbian_mult
XMPRED_r_16_8  i_pred_16  vw_route_16_8  vss  vss  sky130_fd_pr__nfet_01v8  w=4  l=0.35
Cw_route_16_8  vw_route_16_8  vss  200f
R_bleed_16_8  vw_route_16_8  vss  10000meg
XMN4_r_16_8  vw_route_16_8  we_route  iwrite_route_16_8  vss  sky130_fd_pr__nfet_01v8  w=0.5  l=0.5
X_rhebb_16_8  iwrite_route_16_8  inp_upper_8  ierr_dig_16  vcm_route  vdd vss  hebbian_mult
XMPRED_r_16_9  i_pred_16  vw_route_16_9  vss  vss  sky130_fd_pr__nfet_01v8  w=4  l=0.35
Cw_route_16_9  vw_route_16_9  vss  200f
R_bleed_16_9  vw_route_16_9  vss  10000meg
XMN4_r_16_9  vw_route_16_9  we_route  iwrite_route_16_9  vss  sky130_fd_pr__nfet_01v8  w=0.5  l=0.5
X_rhebb_16_9  iwrite_route_16_9  inp_upper_9  ierr_dig_16  vcm_route  vdd vss  hebbian_mult
XMPRED_r_16_10  i_pred_16  vw_route_16_10  vss  vss  sky130_fd_pr__nfet_01v8  w=4  l=0.35
Cw_route_16_10  vw_route_16_10  vss  200f
R_bleed_16_10  vw_route_16_10  vss  10000meg
XMN4_r_16_10  vw_route_16_10  we_route  iwrite_route_16_10  vss  sky130_fd_pr__nfet_01v8  w=0.5  l=0.5
X_rhebb_16_10  iwrite_route_16_10  inp_upper_10  ierr_dig_16  vcm_route  vdd vss  hebbian_mult
XMPRED_r_16_11  i_pred_16  vw_route_16_11  vss  vss  sky130_fd_pr__nfet_01v8  w=4  l=0.35
Cw_route_16_11  vw_route_16_11  vss  200f
R_bleed_16_11  vw_route_16_11  vss  10000meg
XMN4_r_16_11  vw_route_16_11  we_route  iwrite_route_16_11  vss  sky130_fd_pr__nfet_01v8  w=0.5  l=0.5
X_rhebb_16_11  iwrite_route_16_11  inp_upper_11  ierr_dig_16  vcm_route  vdd vss  hebbian_mult
XMPRED_r_16_12  i_pred_16  vw_route_16_12  vss  vss  sky130_fd_pr__nfet_01v8  w=4  l=0.35
Cw_route_16_12  vw_route_16_12  vss  200f
R_bleed_16_12  vw_route_16_12  vss  10000meg
XMN4_r_16_12  vw_route_16_12  we_route  iwrite_route_16_12  vss  sky130_fd_pr__nfet_01v8  w=0.5  l=0.5
X_rhebb_16_12  iwrite_route_16_12  inp_upper_12  ierr_dig_16  vcm_route  vdd vss  hebbian_mult
XMPRED_r_16_13  i_pred_16  vw_route_16_13  vss  vss  sky130_fd_pr__nfet_01v8  w=4  l=0.35
Cw_route_16_13  vw_route_16_13  vss  200f
R_bleed_16_13  vw_route_16_13  vss  10000meg
XMN4_r_16_13  vw_route_16_13  we_route  iwrite_route_16_13  vss  sky130_fd_pr__nfet_01v8  w=0.5  l=0.5
X_rhebb_16_13  iwrite_route_16_13  inp_upper_13  ierr_dig_16  vcm_route  vdd vss  hebbian_mult
XMPRED_r_16_14  i_pred_16  vw_route_16_14  vss  vss  sky130_fd_pr__nfet_01v8  w=4  l=0.35
Cw_route_16_14  vw_route_16_14  vss  200f
R_bleed_16_14  vw_route_16_14  vss  10000meg
XMN4_r_16_14  vw_route_16_14  we_route  iwrite_route_16_14  vss  sky130_fd_pr__nfet_01v8  w=0.5  l=0.5
X_rhebb_16_14  iwrite_route_16_14  inp_upper_14  ierr_dig_16  vcm_route  vdd vss  hebbian_mult
XMPRED_r_16_15  i_pred_16  vw_route_16_15  vss  vss  sky130_fd_pr__nfet_01v8  w=4  l=0.35
Cw_route_16_15  vw_route_16_15  vss  200f
R_bleed_16_15  vw_route_16_15  vss  10000meg
XMN4_r_16_15  vw_route_16_15  we_route  iwrite_route_16_15  vss  sky130_fd_pr__nfet_01v8  w=0.5  l=0.5
X_rhebb_16_15  iwrite_route_16_15  inp_upper_15  ierr_dig_16  vcm_route  vdd vss  hebbian_mult
XMPRED_r_16_16  i_pred_16  vw_route_16_16  vss  vss  sky130_fd_pr__nfet_01v8  w=4  l=0.35
Cw_route_16_16  vw_route_16_16  vss  200f
R_bleed_16_16  vw_route_16_16  vss  10000meg
XMN4_r_16_16  vw_route_16_16  we_route  iwrite_route_16_16  vss  sky130_fd_pr__nfet_01v8  w=0.5  l=0.5
X_rhebb_16_16  iwrite_route_16_16  inp_upper_16  ierr_dig_16  vcm_route  vdd vss  hebbian_mult
XMPRED_r_16_17  i_pred_16  vw_route_16_17  vss  vss  sky130_fd_pr__nfet_01v8  w=4  l=0.35
Cw_route_16_17  vw_route_16_17  vss  200f
R_bleed_16_17  vw_route_16_17  vss  10000meg
XMN4_r_16_17  vw_route_16_17  we_route  iwrite_route_16_17  vss  sky130_fd_pr__nfet_01v8  w=0.5  l=0.5
X_rhebb_16_17  iwrite_route_16_17  inp_upper_17  ierr_dig_16  vcm_route  vdd vss  hebbian_mult
XMPRED_r_16_18  i_pred_16  vw_route_16_18  vss  vss  sky130_fd_pr__nfet_01v8  w=4  l=0.35
Cw_route_16_18  vw_route_16_18  vss  200f
R_bleed_16_18  vw_route_16_18  vss  10000meg
XMN4_r_16_18  vw_route_16_18  we_route  iwrite_route_16_18  vss  sky130_fd_pr__nfet_01v8  w=0.5  l=0.5
X_rhebb_16_18  iwrite_route_16_18  inp_upper_18  ierr_dig_16  vcm_route  vdd vss  hebbian_mult
XMPRED_r_16_19  i_pred_16  vw_route_16_19  vss  vss  sky130_fd_pr__nfet_01v8  w=4  l=0.35
Cw_route_16_19  vw_route_16_19  vss  200f
R_bleed_16_19  vw_route_16_19  vss  10000meg
XMN4_r_16_19  vw_route_16_19  we_route  iwrite_route_16_19  vss  sky130_fd_pr__nfet_01v8  w=0.5  l=0.5
X_rhebb_16_19  iwrite_route_16_19  inp_upper_19  ierr_dig_16  vcm_route  vdd vss  hebbian_mult
XMPRED_r_16_20  i_pred_16  vw_route_16_20  vss  vss  sky130_fd_pr__nfet_01v8  w=4  l=0.35
Cw_route_16_20  vw_route_16_20  vss  200f
R_bleed_16_20  vw_route_16_20  vss  10000meg
XMN4_r_16_20  vw_route_16_20  we_route  iwrite_route_16_20  vss  sky130_fd_pr__nfet_01v8  w=0.5  l=0.5
X_rhebb_16_20  iwrite_route_16_20  inp_upper_20  ierr_dig_16  vcm_route  vdd vss  hebbian_mult
XMPRED_r_16_21  i_pred_16  vw_route_16_21  vss  vss  sky130_fd_pr__nfet_01v8  w=4  l=0.35
Cw_route_16_21  vw_route_16_21  vss  200f
R_bleed_16_21  vw_route_16_21  vss  10000meg
XMN4_r_16_21  vw_route_16_21  we_route  iwrite_route_16_21  vss  sky130_fd_pr__nfet_01v8  w=0.5  l=0.5
X_rhebb_16_21  iwrite_route_16_21  inp_upper_21  ierr_dig_16  vcm_route  vdd vss  hebbian_mult
XMPRED_r_16_22  i_pred_16  vw_route_16_22  vss  vss  sky130_fd_pr__nfet_01v8  w=4  l=0.35
Cw_route_16_22  vw_route_16_22  vss  200f
R_bleed_16_22  vw_route_16_22  vss  10000meg
XMN4_r_16_22  vw_route_16_22  we_route  iwrite_route_16_22  vss  sky130_fd_pr__nfet_01v8  w=0.5  l=0.5
X_rhebb_16_22  iwrite_route_16_22  inp_upper_22  ierr_dig_16  vcm_route  vdd vss  hebbian_mult
XMPRED_r_16_23  i_pred_16  vw_route_16_23  vss  vss  sky130_fd_pr__nfet_01v8  w=4  l=0.35
Cw_route_16_23  vw_route_16_23  vss  200f
R_bleed_16_23  vw_route_16_23  vss  10000meg
XMN4_r_16_23  vw_route_16_23  we_route  iwrite_route_16_23  vss  sky130_fd_pr__nfet_01v8  w=0.5  l=0.5
X_rhebb_16_23  iwrite_route_16_23  inp_upper_23  ierr_dig_16  vcm_route  vdd vss  hebbian_mult
XMPRED_r_16_24  i_pred_16  vw_route_16_24  vss  vss  sky130_fd_pr__nfet_01v8  w=4  l=0.35
Cw_route_16_24  vw_route_16_24  vss  200f
R_bleed_16_24  vw_route_16_24  vss  10000meg
XMN4_r_16_24  vw_route_16_24  we_route  iwrite_route_16_24  vss  sky130_fd_pr__nfet_01v8  w=0.5  l=0.5
X_rhebb_16_24  iwrite_route_16_24  inp_upper_24  ierr_dig_16  vcm_route  vdd vss  hebbian_mult
XMPRED_r_16_25  i_pred_16  vw_route_16_25  vss  vss  sky130_fd_pr__nfet_01v8  w=4  l=0.35
Cw_route_16_25  vw_route_16_25  vss  200f
R_bleed_16_25  vw_route_16_25  vss  10000meg
XMN4_r_16_25  vw_route_16_25  we_route  iwrite_route_16_25  vss  sky130_fd_pr__nfet_01v8  w=0.5  l=0.5
X_rhebb_16_25  iwrite_route_16_25  inp_upper_25  ierr_dig_16  vcm_route  vdd vss  hebbian_mult
XMPRED_r_16_26  i_pred_16  vw_route_16_26  vss  vss  sky130_fd_pr__nfet_01v8  w=4  l=0.35
Cw_route_16_26  vw_route_16_26  vss  200f
R_bleed_16_26  vw_route_16_26  vss  10000meg
XMN4_r_16_26  vw_route_16_26  we_route  iwrite_route_16_26  vss  sky130_fd_pr__nfet_01v8  w=0.5  l=0.5
X_rhebb_16_26  iwrite_route_16_26  inp_upper_26  ierr_dig_16  vcm_route  vdd vss  hebbian_mult
XMPRED_r_16_27  i_pred_16  vw_route_16_27  vss  vss  sky130_fd_pr__nfet_01v8  w=4  l=0.35
Cw_route_16_27  vw_route_16_27  vss  200f
R_bleed_16_27  vw_route_16_27  vss  10000meg
XMN4_r_16_27  vw_route_16_27  we_route  iwrite_route_16_27  vss  sky130_fd_pr__nfet_01v8  w=0.5  l=0.5
X_rhebb_16_27  iwrite_route_16_27  inp_upper_27  ierr_dig_16  vcm_route  vdd vss  hebbian_mult
XMPRED_r_16_28  i_pred_16  vw_route_16_28  vss  vss  sky130_fd_pr__nfet_01v8  w=4  l=0.35
Cw_route_16_28  vw_route_16_28  vss  200f
R_bleed_16_28  vw_route_16_28  vss  10000meg
XMN4_r_16_28  vw_route_16_28  we_route  iwrite_route_16_28  vss  sky130_fd_pr__nfet_01v8  w=0.5  l=0.5
X_rhebb_16_28  iwrite_route_16_28  inp_upper_28  ierr_dig_16  vcm_route  vdd vss  hebbian_mult
XMPRED_r_16_29  i_pred_16  vw_route_16_29  vss  vss  sky130_fd_pr__nfet_01v8  w=4  l=0.35
Cw_route_16_29  vw_route_16_29  vss  200f
R_bleed_16_29  vw_route_16_29  vss  10000meg
XMN4_r_16_29  vw_route_16_29  we_route  iwrite_route_16_29  vss  sky130_fd_pr__nfet_01v8  w=0.5  l=0.5
X_rhebb_16_29  iwrite_route_16_29  inp_upper_29  ierr_dig_16  vcm_route  vdd vss  hebbian_mult
XMPRED_r_16_30  i_pred_16  vw_route_16_30  vss  vss  sky130_fd_pr__nfet_01v8  w=4  l=0.35
Cw_route_16_30  vw_route_16_30  vss  200f
R_bleed_16_30  vw_route_16_30  vss  10000meg
XMN4_r_16_30  vw_route_16_30  we_route  iwrite_route_16_30  vss  sky130_fd_pr__nfet_01v8  w=0.5  l=0.5
X_rhebb_16_30  iwrite_route_16_30  inp_upper_30  ierr_dig_16  vcm_route  vdd vss  hebbian_mult
XMPRED_r_16_31  i_pred_16  vw_route_16_31  vss  vss  sky130_fd_pr__nfet_01v8  w=4  l=0.35
Cw_route_16_31  vw_route_16_31  vss  200f
R_bleed_16_31  vw_route_16_31  vss  10000meg
XMN4_r_16_31  vw_route_16_31  we_route  iwrite_route_16_31  vss  sky130_fd_pr__nfet_01v8  w=0.5  l=0.5
X_rhebb_16_31  iwrite_route_16_31  inp_upper_31  ierr_dig_16  vcm_route  vdd vss  hebbian_mult

* ── Destination row 17 ── 32 source connections ──────────────────────────
XMPRED_r_17_0  i_pred_17  vw_route_17_0  vss  vss  sky130_fd_pr__nfet_01v8  w=4  l=0.35
Cw_route_17_0  vw_route_17_0  vss  200f
R_bleed_17_0  vw_route_17_0  vss  10000meg
XMN4_r_17_0  vw_route_17_0  we_route  iwrite_route_17_0  vss  sky130_fd_pr__nfet_01v8  w=0.5  l=0.5
X_rhebb_17_0  iwrite_route_17_0  inp_upper_0  ierr_dig_17  vcm_route  vdd vss  hebbian_mult
XMPRED_r_17_1  i_pred_17  vw_route_17_1  vss  vss  sky130_fd_pr__nfet_01v8  w=4  l=0.35
Cw_route_17_1  vw_route_17_1  vss  200f
R_bleed_17_1  vw_route_17_1  vss  10000meg
XMN4_r_17_1  vw_route_17_1  we_route  iwrite_route_17_1  vss  sky130_fd_pr__nfet_01v8  w=0.5  l=0.5
X_rhebb_17_1  iwrite_route_17_1  inp_upper_1  ierr_dig_17  vcm_route  vdd vss  hebbian_mult
XMPRED_r_17_2  i_pred_17  vw_route_17_2  vss  vss  sky130_fd_pr__nfet_01v8  w=4  l=0.35
Cw_route_17_2  vw_route_17_2  vss  200f
R_bleed_17_2  vw_route_17_2  vss  10000meg
XMN4_r_17_2  vw_route_17_2  we_route  iwrite_route_17_2  vss  sky130_fd_pr__nfet_01v8  w=0.5  l=0.5
X_rhebb_17_2  iwrite_route_17_2  inp_upper_2  ierr_dig_17  vcm_route  vdd vss  hebbian_mult
XMPRED_r_17_3  i_pred_17  vw_route_17_3  vss  vss  sky130_fd_pr__nfet_01v8  w=4  l=0.35
Cw_route_17_3  vw_route_17_3  vss  200f
R_bleed_17_3  vw_route_17_3  vss  10000meg
XMN4_r_17_3  vw_route_17_3  we_route  iwrite_route_17_3  vss  sky130_fd_pr__nfet_01v8  w=0.5  l=0.5
X_rhebb_17_3  iwrite_route_17_3  inp_upper_3  ierr_dig_17  vcm_route  vdd vss  hebbian_mult
XMPRED_r_17_4  i_pred_17  vw_route_17_4  vss  vss  sky130_fd_pr__nfet_01v8  w=4  l=0.35
Cw_route_17_4  vw_route_17_4  vss  200f
R_bleed_17_4  vw_route_17_4  vss  10000meg
XMN4_r_17_4  vw_route_17_4  we_route  iwrite_route_17_4  vss  sky130_fd_pr__nfet_01v8  w=0.5  l=0.5
X_rhebb_17_4  iwrite_route_17_4  inp_upper_4  ierr_dig_17  vcm_route  vdd vss  hebbian_mult
XMPRED_r_17_5  i_pred_17  vw_route_17_5  vss  vss  sky130_fd_pr__nfet_01v8  w=4  l=0.35
Cw_route_17_5  vw_route_17_5  vss  200f
R_bleed_17_5  vw_route_17_5  vss  10000meg
XMN4_r_17_5  vw_route_17_5  we_route  iwrite_route_17_5  vss  sky130_fd_pr__nfet_01v8  w=0.5  l=0.5
X_rhebb_17_5  iwrite_route_17_5  inp_upper_5  ierr_dig_17  vcm_route  vdd vss  hebbian_mult
XMPRED_r_17_6  i_pred_17  vw_route_17_6  vss  vss  sky130_fd_pr__nfet_01v8  w=4  l=0.35
Cw_route_17_6  vw_route_17_6  vss  200f
R_bleed_17_6  vw_route_17_6  vss  10000meg
XMN4_r_17_6  vw_route_17_6  we_route  iwrite_route_17_6  vss  sky130_fd_pr__nfet_01v8  w=0.5  l=0.5
X_rhebb_17_6  iwrite_route_17_6  inp_upper_6  ierr_dig_17  vcm_route  vdd vss  hebbian_mult
XMPRED_r_17_7  i_pred_17  vw_route_17_7  vss  vss  sky130_fd_pr__nfet_01v8  w=4  l=0.35
Cw_route_17_7  vw_route_17_7  vss  200f
R_bleed_17_7  vw_route_17_7  vss  10000meg
XMN4_r_17_7  vw_route_17_7  we_route  iwrite_route_17_7  vss  sky130_fd_pr__nfet_01v8  w=0.5  l=0.5
X_rhebb_17_7  iwrite_route_17_7  inp_upper_7  ierr_dig_17  vcm_route  vdd vss  hebbian_mult
XMPRED_r_17_8  i_pred_17  vw_route_17_8  vss  vss  sky130_fd_pr__nfet_01v8  w=4  l=0.35
Cw_route_17_8  vw_route_17_8  vss  200f
R_bleed_17_8  vw_route_17_8  vss  10000meg
XMN4_r_17_8  vw_route_17_8  we_route  iwrite_route_17_8  vss  sky130_fd_pr__nfet_01v8  w=0.5  l=0.5
X_rhebb_17_8  iwrite_route_17_8  inp_upper_8  ierr_dig_17  vcm_route  vdd vss  hebbian_mult
XMPRED_r_17_9  i_pred_17  vw_route_17_9  vss  vss  sky130_fd_pr__nfet_01v8  w=4  l=0.35
Cw_route_17_9  vw_route_17_9  vss  200f
R_bleed_17_9  vw_route_17_9  vss  10000meg
XMN4_r_17_9  vw_route_17_9  we_route  iwrite_route_17_9  vss  sky130_fd_pr__nfet_01v8  w=0.5  l=0.5
X_rhebb_17_9  iwrite_route_17_9  inp_upper_9  ierr_dig_17  vcm_route  vdd vss  hebbian_mult
XMPRED_r_17_10  i_pred_17  vw_route_17_10  vss  vss  sky130_fd_pr__nfet_01v8  w=4  l=0.35
Cw_route_17_10  vw_route_17_10  vss  200f
R_bleed_17_10  vw_route_17_10  vss  10000meg
XMN4_r_17_10  vw_route_17_10  we_route  iwrite_route_17_10  vss  sky130_fd_pr__nfet_01v8  w=0.5  l=0.5
X_rhebb_17_10  iwrite_route_17_10  inp_upper_10  ierr_dig_17  vcm_route  vdd vss  hebbian_mult
XMPRED_r_17_11  i_pred_17  vw_route_17_11  vss  vss  sky130_fd_pr__nfet_01v8  w=4  l=0.35
Cw_route_17_11  vw_route_17_11  vss  200f
R_bleed_17_11  vw_route_17_11  vss  10000meg
XMN4_r_17_11  vw_route_17_11  we_route  iwrite_route_17_11  vss  sky130_fd_pr__nfet_01v8  w=0.5  l=0.5
X_rhebb_17_11  iwrite_route_17_11  inp_upper_11  ierr_dig_17  vcm_route  vdd vss  hebbian_mult
XMPRED_r_17_12  i_pred_17  vw_route_17_12  vss  vss  sky130_fd_pr__nfet_01v8  w=4  l=0.35
Cw_route_17_12  vw_route_17_12  vss  200f
R_bleed_17_12  vw_route_17_12  vss  10000meg
XMN4_r_17_12  vw_route_17_12  we_route  iwrite_route_17_12  vss  sky130_fd_pr__nfet_01v8  w=0.5  l=0.5
X_rhebb_17_12  iwrite_route_17_12  inp_upper_12  ierr_dig_17  vcm_route  vdd vss  hebbian_mult
XMPRED_r_17_13  i_pred_17  vw_route_17_13  vss  vss  sky130_fd_pr__nfet_01v8  w=4  l=0.35
Cw_route_17_13  vw_route_17_13  vss  200f
R_bleed_17_13  vw_route_17_13  vss  10000meg
XMN4_r_17_13  vw_route_17_13  we_route  iwrite_route_17_13  vss  sky130_fd_pr__nfet_01v8  w=0.5  l=0.5
X_rhebb_17_13  iwrite_route_17_13  inp_upper_13  ierr_dig_17  vcm_route  vdd vss  hebbian_mult
XMPRED_r_17_14  i_pred_17  vw_route_17_14  vss  vss  sky130_fd_pr__nfet_01v8  w=4  l=0.35
Cw_route_17_14  vw_route_17_14  vss  200f
R_bleed_17_14  vw_route_17_14  vss  10000meg
XMN4_r_17_14  vw_route_17_14  we_route  iwrite_route_17_14  vss  sky130_fd_pr__nfet_01v8  w=0.5  l=0.5
X_rhebb_17_14  iwrite_route_17_14  inp_upper_14  ierr_dig_17  vcm_route  vdd vss  hebbian_mult
XMPRED_r_17_15  i_pred_17  vw_route_17_15  vss  vss  sky130_fd_pr__nfet_01v8  w=4  l=0.35
Cw_route_17_15  vw_route_17_15  vss  200f
R_bleed_17_15  vw_route_17_15  vss  10000meg
XMN4_r_17_15  vw_route_17_15  we_route  iwrite_route_17_15  vss  sky130_fd_pr__nfet_01v8  w=0.5  l=0.5
X_rhebb_17_15  iwrite_route_17_15  inp_upper_15  ierr_dig_17  vcm_route  vdd vss  hebbian_mult
XMPRED_r_17_16  i_pred_17  vw_route_17_16  vss  vss  sky130_fd_pr__nfet_01v8  w=4  l=0.35
Cw_route_17_16  vw_route_17_16  vss  200f
R_bleed_17_16  vw_route_17_16  vss  10000meg
XMN4_r_17_16  vw_route_17_16  we_route  iwrite_route_17_16  vss  sky130_fd_pr__nfet_01v8  w=0.5  l=0.5
X_rhebb_17_16  iwrite_route_17_16  inp_upper_16  ierr_dig_17  vcm_route  vdd vss  hebbian_mult
XMPRED_r_17_17  i_pred_17  vw_route_17_17  vss  vss  sky130_fd_pr__nfet_01v8  w=4  l=0.35
Cw_route_17_17  vw_route_17_17  vss  200f
R_bleed_17_17  vw_route_17_17  vss  10000meg
XMN4_r_17_17  vw_route_17_17  we_route  iwrite_route_17_17  vss  sky130_fd_pr__nfet_01v8  w=0.5  l=0.5
X_rhebb_17_17  iwrite_route_17_17  inp_upper_17  ierr_dig_17  vcm_route  vdd vss  hebbian_mult
XMPRED_r_17_18  i_pred_17  vw_route_17_18  vss  vss  sky130_fd_pr__nfet_01v8  w=4  l=0.35
Cw_route_17_18  vw_route_17_18  vss  200f
R_bleed_17_18  vw_route_17_18  vss  10000meg
XMN4_r_17_18  vw_route_17_18  we_route  iwrite_route_17_18  vss  sky130_fd_pr__nfet_01v8  w=0.5  l=0.5
X_rhebb_17_18  iwrite_route_17_18  inp_upper_18  ierr_dig_17  vcm_route  vdd vss  hebbian_mult
XMPRED_r_17_19  i_pred_17  vw_route_17_19  vss  vss  sky130_fd_pr__nfet_01v8  w=4  l=0.35
Cw_route_17_19  vw_route_17_19  vss  200f
R_bleed_17_19  vw_route_17_19  vss  10000meg
XMN4_r_17_19  vw_route_17_19  we_route  iwrite_route_17_19  vss  sky130_fd_pr__nfet_01v8  w=0.5  l=0.5
X_rhebb_17_19  iwrite_route_17_19  inp_upper_19  ierr_dig_17  vcm_route  vdd vss  hebbian_mult
XMPRED_r_17_20  i_pred_17  vw_route_17_20  vss  vss  sky130_fd_pr__nfet_01v8  w=4  l=0.35
Cw_route_17_20  vw_route_17_20  vss  200f
R_bleed_17_20  vw_route_17_20  vss  10000meg
XMN4_r_17_20  vw_route_17_20  we_route  iwrite_route_17_20  vss  sky130_fd_pr__nfet_01v8  w=0.5  l=0.5
X_rhebb_17_20  iwrite_route_17_20  inp_upper_20  ierr_dig_17  vcm_route  vdd vss  hebbian_mult
XMPRED_r_17_21  i_pred_17  vw_route_17_21  vss  vss  sky130_fd_pr__nfet_01v8  w=4  l=0.35
Cw_route_17_21  vw_route_17_21  vss  200f
R_bleed_17_21  vw_route_17_21  vss  10000meg
XMN4_r_17_21  vw_route_17_21  we_route  iwrite_route_17_21  vss  sky130_fd_pr__nfet_01v8  w=0.5  l=0.5
X_rhebb_17_21  iwrite_route_17_21  inp_upper_21  ierr_dig_17  vcm_route  vdd vss  hebbian_mult
XMPRED_r_17_22  i_pred_17  vw_route_17_22  vss  vss  sky130_fd_pr__nfet_01v8  w=4  l=0.35
Cw_route_17_22  vw_route_17_22  vss  200f
R_bleed_17_22  vw_route_17_22  vss  10000meg
XMN4_r_17_22  vw_route_17_22  we_route  iwrite_route_17_22  vss  sky130_fd_pr__nfet_01v8  w=0.5  l=0.5
X_rhebb_17_22  iwrite_route_17_22  inp_upper_22  ierr_dig_17  vcm_route  vdd vss  hebbian_mult
XMPRED_r_17_23  i_pred_17  vw_route_17_23  vss  vss  sky130_fd_pr__nfet_01v8  w=4  l=0.35
Cw_route_17_23  vw_route_17_23  vss  200f
R_bleed_17_23  vw_route_17_23  vss  10000meg
XMN4_r_17_23  vw_route_17_23  we_route  iwrite_route_17_23  vss  sky130_fd_pr__nfet_01v8  w=0.5  l=0.5
X_rhebb_17_23  iwrite_route_17_23  inp_upper_23  ierr_dig_17  vcm_route  vdd vss  hebbian_mult
XMPRED_r_17_24  i_pred_17  vw_route_17_24  vss  vss  sky130_fd_pr__nfet_01v8  w=4  l=0.35
Cw_route_17_24  vw_route_17_24  vss  200f
R_bleed_17_24  vw_route_17_24  vss  10000meg
XMN4_r_17_24  vw_route_17_24  we_route  iwrite_route_17_24  vss  sky130_fd_pr__nfet_01v8  w=0.5  l=0.5
X_rhebb_17_24  iwrite_route_17_24  inp_upper_24  ierr_dig_17  vcm_route  vdd vss  hebbian_mult
XMPRED_r_17_25  i_pred_17  vw_route_17_25  vss  vss  sky130_fd_pr__nfet_01v8  w=4  l=0.35
Cw_route_17_25  vw_route_17_25  vss  200f
R_bleed_17_25  vw_route_17_25  vss  10000meg
XMN4_r_17_25  vw_route_17_25  we_route  iwrite_route_17_25  vss  sky130_fd_pr__nfet_01v8  w=0.5  l=0.5
X_rhebb_17_25  iwrite_route_17_25  inp_upper_25  ierr_dig_17  vcm_route  vdd vss  hebbian_mult
XMPRED_r_17_26  i_pred_17  vw_route_17_26  vss  vss  sky130_fd_pr__nfet_01v8  w=4  l=0.35
Cw_route_17_26  vw_route_17_26  vss  200f
R_bleed_17_26  vw_route_17_26  vss  10000meg
XMN4_r_17_26  vw_route_17_26  we_route  iwrite_route_17_26  vss  sky130_fd_pr__nfet_01v8  w=0.5  l=0.5
X_rhebb_17_26  iwrite_route_17_26  inp_upper_26  ierr_dig_17  vcm_route  vdd vss  hebbian_mult
XMPRED_r_17_27  i_pred_17  vw_route_17_27  vss  vss  sky130_fd_pr__nfet_01v8  w=4  l=0.35
Cw_route_17_27  vw_route_17_27  vss  200f
R_bleed_17_27  vw_route_17_27  vss  10000meg
XMN4_r_17_27  vw_route_17_27  we_route  iwrite_route_17_27  vss  sky130_fd_pr__nfet_01v8  w=0.5  l=0.5
X_rhebb_17_27  iwrite_route_17_27  inp_upper_27  ierr_dig_17  vcm_route  vdd vss  hebbian_mult
XMPRED_r_17_28  i_pred_17  vw_route_17_28  vss  vss  sky130_fd_pr__nfet_01v8  w=4  l=0.35
Cw_route_17_28  vw_route_17_28  vss  200f
R_bleed_17_28  vw_route_17_28  vss  10000meg
XMN4_r_17_28  vw_route_17_28  we_route  iwrite_route_17_28  vss  sky130_fd_pr__nfet_01v8  w=0.5  l=0.5
X_rhebb_17_28  iwrite_route_17_28  inp_upper_28  ierr_dig_17  vcm_route  vdd vss  hebbian_mult
XMPRED_r_17_29  i_pred_17  vw_route_17_29  vss  vss  sky130_fd_pr__nfet_01v8  w=4  l=0.35
Cw_route_17_29  vw_route_17_29  vss  200f
R_bleed_17_29  vw_route_17_29  vss  10000meg
XMN4_r_17_29  vw_route_17_29  we_route  iwrite_route_17_29  vss  sky130_fd_pr__nfet_01v8  w=0.5  l=0.5
X_rhebb_17_29  iwrite_route_17_29  inp_upper_29  ierr_dig_17  vcm_route  vdd vss  hebbian_mult
XMPRED_r_17_30  i_pred_17  vw_route_17_30  vss  vss  sky130_fd_pr__nfet_01v8  w=4  l=0.35
Cw_route_17_30  vw_route_17_30  vss  200f
R_bleed_17_30  vw_route_17_30  vss  10000meg
XMN4_r_17_30  vw_route_17_30  we_route  iwrite_route_17_30  vss  sky130_fd_pr__nfet_01v8  w=0.5  l=0.5
X_rhebb_17_30  iwrite_route_17_30  inp_upper_30  ierr_dig_17  vcm_route  vdd vss  hebbian_mult
XMPRED_r_17_31  i_pred_17  vw_route_17_31  vss  vss  sky130_fd_pr__nfet_01v8  w=4  l=0.35
Cw_route_17_31  vw_route_17_31  vss  200f
R_bleed_17_31  vw_route_17_31  vss  10000meg
XMN4_r_17_31  vw_route_17_31  we_route  iwrite_route_17_31  vss  sky130_fd_pr__nfet_01v8  w=0.5  l=0.5
X_rhebb_17_31  iwrite_route_17_31  inp_upper_31  ierr_dig_17  vcm_route  vdd vss  hebbian_mult

* ── Destination row 18 ── 32 source connections ──────────────────────────
XMPRED_r_18_0  i_pred_18  vw_route_18_0  vss  vss  sky130_fd_pr__nfet_01v8  w=4  l=0.35
Cw_route_18_0  vw_route_18_0  vss  200f
R_bleed_18_0  vw_route_18_0  vss  10000meg
XMN4_r_18_0  vw_route_18_0  we_route  iwrite_route_18_0  vss  sky130_fd_pr__nfet_01v8  w=0.5  l=0.5
X_rhebb_18_0  iwrite_route_18_0  inp_upper_0  ierr_dig_18  vcm_route  vdd vss  hebbian_mult
XMPRED_r_18_1  i_pred_18  vw_route_18_1  vss  vss  sky130_fd_pr__nfet_01v8  w=4  l=0.35
Cw_route_18_1  vw_route_18_1  vss  200f
R_bleed_18_1  vw_route_18_1  vss  10000meg
XMN4_r_18_1  vw_route_18_1  we_route  iwrite_route_18_1  vss  sky130_fd_pr__nfet_01v8  w=0.5  l=0.5
X_rhebb_18_1  iwrite_route_18_1  inp_upper_1  ierr_dig_18  vcm_route  vdd vss  hebbian_mult
XMPRED_r_18_2  i_pred_18  vw_route_18_2  vss  vss  sky130_fd_pr__nfet_01v8  w=4  l=0.35
Cw_route_18_2  vw_route_18_2  vss  200f
R_bleed_18_2  vw_route_18_2  vss  10000meg
XMN4_r_18_2  vw_route_18_2  we_route  iwrite_route_18_2  vss  sky130_fd_pr__nfet_01v8  w=0.5  l=0.5
X_rhebb_18_2  iwrite_route_18_2  inp_upper_2  ierr_dig_18  vcm_route  vdd vss  hebbian_mult
XMPRED_r_18_3  i_pred_18  vw_route_18_3  vss  vss  sky130_fd_pr__nfet_01v8  w=4  l=0.35
Cw_route_18_3  vw_route_18_3  vss  200f
R_bleed_18_3  vw_route_18_3  vss  10000meg
XMN4_r_18_3  vw_route_18_3  we_route  iwrite_route_18_3  vss  sky130_fd_pr__nfet_01v8  w=0.5  l=0.5
X_rhebb_18_3  iwrite_route_18_3  inp_upper_3  ierr_dig_18  vcm_route  vdd vss  hebbian_mult
XMPRED_r_18_4  i_pred_18  vw_route_18_4  vss  vss  sky130_fd_pr__nfet_01v8  w=4  l=0.35
Cw_route_18_4  vw_route_18_4  vss  200f
R_bleed_18_4  vw_route_18_4  vss  10000meg
XMN4_r_18_4  vw_route_18_4  we_route  iwrite_route_18_4  vss  sky130_fd_pr__nfet_01v8  w=0.5  l=0.5
X_rhebb_18_4  iwrite_route_18_4  inp_upper_4  ierr_dig_18  vcm_route  vdd vss  hebbian_mult
XMPRED_r_18_5  i_pred_18  vw_route_18_5  vss  vss  sky130_fd_pr__nfet_01v8  w=4  l=0.35
Cw_route_18_5  vw_route_18_5  vss  200f
R_bleed_18_5  vw_route_18_5  vss  10000meg
XMN4_r_18_5  vw_route_18_5  we_route  iwrite_route_18_5  vss  sky130_fd_pr__nfet_01v8  w=0.5  l=0.5
X_rhebb_18_5  iwrite_route_18_5  inp_upper_5  ierr_dig_18  vcm_route  vdd vss  hebbian_mult
XMPRED_r_18_6  i_pred_18  vw_route_18_6  vss  vss  sky130_fd_pr__nfet_01v8  w=4  l=0.35
Cw_route_18_6  vw_route_18_6  vss  200f
R_bleed_18_6  vw_route_18_6  vss  10000meg
XMN4_r_18_6  vw_route_18_6  we_route  iwrite_route_18_6  vss  sky130_fd_pr__nfet_01v8  w=0.5  l=0.5
X_rhebb_18_6  iwrite_route_18_6  inp_upper_6  ierr_dig_18  vcm_route  vdd vss  hebbian_mult
XMPRED_r_18_7  i_pred_18  vw_route_18_7  vss  vss  sky130_fd_pr__nfet_01v8  w=4  l=0.35
Cw_route_18_7  vw_route_18_7  vss  200f
R_bleed_18_7  vw_route_18_7  vss  10000meg
XMN4_r_18_7  vw_route_18_7  we_route  iwrite_route_18_7  vss  sky130_fd_pr__nfet_01v8  w=0.5  l=0.5
X_rhebb_18_7  iwrite_route_18_7  inp_upper_7  ierr_dig_18  vcm_route  vdd vss  hebbian_mult
XMPRED_r_18_8  i_pred_18  vw_route_18_8  vss  vss  sky130_fd_pr__nfet_01v8  w=4  l=0.35
Cw_route_18_8  vw_route_18_8  vss  200f
R_bleed_18_8  vw_route_18_8  vss  10000meg
XMN4_r_18_8  vw_route_18_8  we_route  iwrite_route_18_8  vss  sky130_fd_pr__nfet_01v8  w=0.5  l=0.5
X_rhebb_18_8  iwrite_route_18_8  inp_upper_8  ierr_dig_18  vcm_route  vdd vss  hebbian_mult
XMPRED_r_18_9  i_pred_18  vw_route_18_9  vss  vss  sky130_fd_pr__nfet_01v8  w=4  l=0.35
Cw_route_18_9  vw_route_18_9  vss  200f
R_bleed_18_9  vw_route_18_9  vss  10000meg
XMN4_r_18_9  vw_route_18_9  we_route  iwrite_route_18_9  vss  sky130_fd_pr__nfet_01v8  w=0.5  l=0.5
X_rhebb_18_9  iwrite_route_18_9  inp_upper_9  ierr_dig_18  vcm_route  vdd vss  hebbian_mult
XMPRED_r_18_10  i_pred_18  vw_route_18_10  vss  vss  sky130_fd_pr__nfet_01v8  w=4  l=0.35
Cw_route_18_10  vw_route_18_10  vss  200f
R_bleed_18_10  vw_route_18_10  vss  10000meg
XMN4_r_18_10  vw_route_18_10  we_route  iwrite_route_18_10  vss  sky130_fd_pr__nfet_01v8  w=0.5  l=0.5
X_rhebb_18_10  iwrite_route_18_10  inp_upper_10  ierr_dig_18  vcm_route  vdd vss  hebbian_mult
XMPRED_r_18_11  i_pred_18  vw_route_18_11  vss  vss  sky130_fd_pr__nfet_01v8  w=4  l=0.35
Cw_route_18_11  vw_route_18_11  vss  200f
R_bleed_18_11  vw_route_18_11  vss  10000meg
XMN4_r_18_11  vw_route_18_11  we_route  iwrite_route_18_11  vss  sky130_fd_pr__nfet_01v8  w=0.5  l=0.5
X_rhebb_18_11  iwrite_route_18_11  inp_upper_11  ierr_dig_18  vcm_route  vdd vss  hebbian_mult
XMPRED_r_18_12  i_pred_18  vw_route_18_12  vss  vss  sky130_fd_pr__nfet_01v8  w=4  l=0.35
Cw_route_18_12  vw_route_18_12  vss  200f
R_bleed_18_12  vw_route_18_12  vss  10000meg
XMN4_r_18_12  vw_route_18_12  we_route  iwrite_route_18_12  vss  sky130_fd_pr__nfet_01v8  w=0.5  l=0.5
X_rhebb_18_12  iwrite_route_18_12  inp_upper_12  ierr_dig_18  vcm_route  vdd vss  hebbian_mult
XMPRED_r_18_13  i_pred_18  vw_route_18_13  vss  vss  sky130_fd_pr__nfet_01v8  w=4  l=0.35
Cw_route_18_13  vw_route_18_13  vss  200f
R_bleed_18_13  vw_route_18_13  vss  10000meg
XMN4_r_18_13  vw_route_18_13  we_route  iwrite_route_18_13  vss  sky130_fd_pr__nfet_01v8  w=0.5  l=0.5
X_rhebb_18_13  iwrite_route_18_13  inp_upper_13  ierr_dig_18  vcm_route  vdd vss  hebbian_mult
XMPRED_r_18_14  i_pred_18  vw_route_18_14  vss  vss  sky130_fd_pr__nfet_01v8  w=4  l=0.35
Cw_route_18_14  vw_route_18_14  vss  200f
R_bleed_18_14  vw_route_18_14  vss  10000meg
XMN4_r_18_14  vw_route_18_14  we_route  iwrite_route_18_14  vss  sky130_fd_pr__nfet_01v8  w=0.5  l=0.5
X_rhebb_18_14  iwrite_route_18_14  inp_upper_14  ierr_dig_18  vcm_route  vdd vss  hebbian_mult
XMPRED_r_18_15  i_pred_18  vw_route_18_15  vss  vss  sky130_fd_pr__nfet_01v8  w=4  l=0.35
Cw_route_18_15  vw_route_18_15  vss  200f
R_bleed_18_15  vw_route_18_15  vss  10000meg
XMN4_r_18_15  vw_route_18_15  we_route  iwrite_route_18_15  vss  sky130_fd_pr__nfet_01v8  w=0.5  l=0.5
X_rhebb_18_15  iwrite_route_18_15  inp_upper_15  ierr_dig_18  vcm_route  vdd vss  hebbian_mult
XMPRED_r_18_16  i_pred_18  vw_route_18_16  vss  vss  sky130_fd_pr__nfet_01v8  w=4  l=0.35
Cw_route_18_16  vw_route_18_16  vss  200f
R_bleed_18_16  vw_route_18_16  vss  10000meg
XMN4_r_18_16  vw_route_18_16  we_route  iwrite_route_18_16  vss  sky130_fd_pr__nfet_01v8  w=0.5  l=0.5
X_rhebb_18_16  iwrite_route_18_16  inp_upper_16  ierr_dig_18  vcm_route  vdd vss  hebbian_mult
XMPRED_r_18_17  i_pred_18  vw_route_18_17  vss  vss  sky130_fd_pr__nfet_01v8  w=4  l=0.35
Cw_route_18_17  vw_route_18_17  vss  200f
R_bleed_18_17  vw_route_18_17  vss  10000meg
XMN4_r_18_17  vw_route_18_17  we_route  iwrite_route_18_17  vss  sky130_fd_pr__nfet_01v8  w=0.5  l=0.5
X_rhebb_18_17  iwrite_route_18_17  inp_upper_17  ierr_dig_18  vcm_route  vdd vss  hebbian_mult
XMPRED_r_18_18  i_pred_18  vw_route_18_18  vss  vss  sky130_fd_pr__nfet_01v8  w=4  l=0.35
Cw_route_18_18  vw_route_18_18  vss  200f
R_bleed_18_18  vw_route_18_18  vss  10000meg
XMN4_r_18_18  vw_route_18_18  we_route  iwrite_route_18_18  vss  sky130_fd_pr__nfet_01v8  w=0.5  l=0.5
X_rhebb_18_18  iwrite_route_18_18  inp_upper_18  ierr_dig_18  vcm_route  vdd vss  hebbian_mult
XMPRED_r_18_19  i_pred_18  vw_route_18_19  vss  vss  sky130_fd_pr__nfet_01v8  w=4  l=0.35
Cw_route_18_19  vw_route_18_19  vss  200f
R_bleed_18_19  vw_route_18_19  vss  10000meg
XMN4_r_18_19  vw_route_18_19  we_route  iwrite_route_18_19  vss  sky130_fd_pr__nfet_01v8  w=0.5  l=0.5
X_rhebb_18_19  iwrite_route_18_19  inp_upper_19  ierr_dig_18  vcm_route  vdd vss  hebbian_mult
XMPRED_r_18_20  i_pred_18  vw_route_18_20  vss  vss  sky130_fd_pr__nfet_01v8  w=4  l=0.35
Cw_route_18_20  vw_route_18_20  vss  200f
R_bleed_18_20  vw_route_18_20  vss  10000meg
XMN4_r_18_20  vw_route_18_20  we_route  iwrite_route_18_20  vss  sky130_fd_pr__nfet_01v8  w=0.5  l=0.5
X_rhebb_18_20  iwrite_route_18_20  inp_upper_20  ierr_dig_18  vcm_route  vdd vss  hebbian_mult
XMPRED_r_18_21  i_pred_18  vw_route_18_21  vss  vss  sky130_fd_pr__nfet_01v8  w=4  l=0.35
Cw_route_18_21  vw_route_18_21  vss  200f
R_bleed_18_21  vw_route_18_21  vss  10000meg
XMN4_r_18_21  vw_route_18_21  we_route  iwrite_route_18_21  vss  sky130_fd_pr__nfet_01v8  w=0.5  l=0.5
X_rhebb_18_21  iwrite_route_18_21  inp_upper_21  ierr_dig_18  vcm_route  vdd vss  hebbian_mult
XMPRED_r_18_22  i_pred_18  vw_route_18_22  vss  vss  sky130_fd_pr__nfet_01v8  w=4  l=0.35
Cw_route_18_22  vw_route_18_22  vss  200f
R_bleed_18_22  vw_route_18_22  vss  10000meg
XMN4_r_18_22  vw_route_18_22  we_route  iwrite_route_18_22  vss  sky130_fd_pr__nfet_01v8  w=0.5  l=0.5
X_rhebb_18_22  iwrite_route_18_22  inp_upper_22  ierr_dig_18  vcm_route  vdd vss  hebbian_mult
XMPRED_r_18_23  i_pred_18  vw_route_18_23  vss  vss  sky130_fd_pr__nfet_01v8  w=4  l=0.35
Cw_route_18_23  vw_route_18_23  vss  200f
R_bleed_18_23  vw_route_18_23  vss  10000meg
XMN4_r_18_23  vw_route_18_23  we_route  iwrite_route_18_23  vss  sky130_fd_pr__nfet_01v8  w=0.5  l=0.5
X_rhebb_18_23  iwrite_route_18_23  inp_upper_23  ierr_dig_18  vcm_route  vdd vss  hebbian_mult
XMPRED_r_18_24  i_pred_18  vw_route_18_24  vss  vss  sky130_fd_pr__nfet_01v8  w=4  l=0.35
Cw_route_18_24  vw_route_18_24  vss  200f
R_bleed_18_24  vw_route_18_24  vss  10000meg
XMN4_r_18_24  vw_route_18_24  we_route  iwrite_route_18_24  vss  sky130_fd_pr__nfet_01v8  w=0.5  l=0.5
X_rhebb_18_24  iwrite_route_18_24  inp_upper_24  ierr_dig_18  vcm_route  vdd vss  hebbian_mult
XMPRED_r_18_25  i_pred_18  vw_route_18_25  vss  vss  sky130_fd_pr__nfet_01v8  w=4  l=0.35
Cw_route_18_25  vw_route_18_25  vss  200f
R_bleed_18_25  vw_route_18_25  vss  10000meg
XMN4_r_18_25  vw_route_18_25  we_route  iwrite_route_18_25  vss  sky130_fd_pr__nfet_01v8  w=0.5  l=0.5
X_rhebb_18_25  iwrite_route_18_25  inp_upper_25  ierr_dig_18  vcm_route  vdd vss  hebbian_mult
XMPRED_r_18_26  i_pred_18  vw_route_18_26  vss  vss  sky130_fd_pr__nfet_01v8  w=4  l=0.35
Cw_route_18_26  vw_route_18_26  vss  200f
R_bleed_18_26  vw_route_18_26  vss  10000meg
XMN4_r_18_26  vw_route_18_26  we_route  iwrite_route_18_26  vss  sky130_fd_pr__nfet_01v8  w=0.5  l=0.5
X_rhebb_18_26  iwrite_route_18_26  inp_upper_26  ierr_dig_18  vcm_route  vdd vss  hebbian_mult
XMPRED_r_18_27  i_pred_18  vw_route_18_27  vss  vss  sky130_fd_pr__nfet_01v8  w=4  l=0.35
Cw_route_18_27  vw_route_18_27  vss  200f
R_bleed_18_27  vw_route_18_27  vss  10000meg
XMN4_r_18_27  vw_route_18_27  we_route  iwrite_route_18_27  vss  sky130_fd_pr__nfet_01v8  w=0.5  l=0.5
X_rhebb_18_27  iwrite_route_18_27  inp_upper_27  ierr_dig_18  vcm_route  vdd vss  hebbian_mult
XMPRED_r_18_28  i_pred_18  vw_route_18_28  vss  vss  sky130_fd_pr__nfet_01v8  w=4  l=0.35
Cw_route_18_28  vw_route_18_28  vss  200f
R_bleed_18_28  vw_route_18_28  vss  10000meg
XMN4_r_18_28  vw_route_18_28  we_route  iwrite_route_18_28  vss  sky130_fd_pr__nfet_01v8  w=0.5  l=0.5
X_rhebb_18_28  iwrite_route_18_28  inp_upper_28  ierr_dig_18  vcm_route  vdd vss  hebbian_mult
XMPRED_r_18_29  i_pred_18  vw_route_18_29  vss  vss  sky130_fd_pr__nfet_01v8  w=4  l=0.35
Cw_route_18_29  vw_route_18_29  vss  200f
R_bleed_18_29  vw_route_18_29  vss  10000meg
XMN4_r_18_29  vw_route_18_29  we_route  iwrite_route_18_29  vss  sky130_fd_pr__nfet_01v8  w=0.5  l=0.5
X_rhebb_18_29  iwrite_route_18_29  inp_upper_29  ierr_dig_18  vcm_route  vdd vss  hebbian_mult
XMPRED_r_18_30  i_pred_18  vw_route_18_30  vss  vss  sky130_fd_pr__nfet_01v8  w=4  l=0.35
Cw_route_18_30  vw_route_18_30  vss  200f
R_bleed_18_30  vw_route_18_30  vss  10000meg
XMN4_r_18_30  vw_route_18_30  we_route  iwrite_route_18_30  vss  sky130_fd_pr__nfet_01v8  w=0.5  l=0.5
X_rhebb_18_30  iwrite_route_18_30  inp_upper_30  ierr_dig_18  vcm_route  vdd vss  hebbian_mult
XMPRED_r_18_31  i_pred_18  vw_route_18_31  vss  vss  sky130_fd_pr__nfet_01v8  w=4  l=0.35
Cw_route_18_31  vw_route_18_31  vss  200f
R_bleed_18_31  vw_route_18_31  vss  10000meg
XMN4_r_18_31  vw_route_18_31  we_route  iwrite_route_18_31  vss  sky130_fd_pr__nfet_01v8  w=0.5  l=0.5
X_rhebb_18_31  iwrite_route_18_31  inp_upper_31  ierr_dig_18  vcm_route  vdd vss  hebbian_mult

* ── Destination row 19 ── 32 source connections ──────────────────────────
XMPRED_r_19_0  i_pred_19  vw_route_19_0  vss  vss  sky130_fd_pr__nfet_01v8  w=4  l=0.35
Cw_route_19_0  vw_route_19_0  vss  200f
R_bleed_19_0  vw_route_19_0  vss  10000meg
XMN4_r_19_0  vw_route_19_0  we_route  iwrite_route_19_0  vss  sky130_fd_pr__nfet_01v8  w=0.5  l=0.5
X_rhebb_19_0  iwrite_route_19_0  inp_upper_0  ierr_dig_19  vcm_route  vdd vss  hebbian_mult
XMPRED_r_19_1  i_pred_19  vw_route_19_1  vss  vss  sky130_fd_pr__nfet_01v8  w=4  l=0.35
Cw_route_19_1  vw_route_19_1  vss  200f
R_bleed_19_1  vw_route_19_1  vss  10000meg
XMN4_r_19_1  vw_route_19_1  we_route  iwrite_route_19_1  vss  sky130_fd_pr__nfet_01v8  w=0.5  l=0.5
X_rhebb_19_1  iwrite_route_19_1  inp_upper_1  ierr_dig_19  vcm_route  vdd vss  hebbian_mult
XMPRED_r_19_2  i_pred_19  vw_route_19_2  vss  vss  sky130_fd_pr__nfet_01v8  w=4  l=0.35
Cw_route_19_2  vw_route_19_2  vss  200f
R_bleed_19_2  vw_route_19_2  vss  10000meg
XMN4_r_19_2  vw_route_19_2  we_route  iwrite_route_19_2  vss  sky130_fd_pr__nfet_01v8  w=0.5  l=0.5
X_rhebb_19_2  iwrite_route_19_2  inp_upper_2  ierr_dig_19  vcm_route  vdd vss  hebbian_mult
XMPRED_r_19_3  i_pred_19  vw_route_19_3  vss  vss  sky130_fd_pr__nfet_01v8  w=4  l=0.35
Cw_route_19_3  vw_route_19_3  vss  200f
R_bleed_19_3  vw_route_19_3  vss  10000meg
XMN4_r_19_3  vw_route_19_3  we_route  iwrite_route_19_3  vss  sky130_fd_pr__nfet_01v8  w=0.5  l=0.5
X_rhebb_19_3  iwrite_route_19_3  inp_upper_3  ierr_dig_19  vcm_route  vdd vss  hebbian_mult
XMPRED_r_19_4  i_pred_19  vw_route_19_4  vss  vss  sky130_fd_pr__nfet_01v8  w=4  l=0.35
Cw_route_19_4  vw_route_19_4  vss  200f
R_bleed_19_4  vw_route_19_4  vss  10000meg
XMN4_r_19_4  vw_route_19_4  we_route  iwrite_route_19_4  vss  sky130_fd_pr__nfet_01v8  w=0.5  l=0.5
X_rhebb_19_4  iwrite_route_19_4  inp_upper_4  ierr_dig_19  vcm_route  vdd vss  hebbian_mult
XMPRED_r_19_5  i_pred_19  vw_route_19_5  vss  vss  sky130_fd_pr__nfet_01v8  w=4  l=0.35
Cw_route_19_5  vw_route_19_5  vss  200f
R_bleed_19_5  vw_route_19_5  vss  10000meg
XMN4_r_19_5  vw_route_19_5  we_route  iwrite_route_19_5  vss  sky130_fd_pr__nfet_01v8  w=0.5  l=0.5
X_rhebb_19_5  iwrite_route_19_5  inp_upper_5  ierr_dig_19  vcm_route  vdd vss  hebbian_mult
XMPRED_r_19_6  i_pred_19  vw_route_19_6  vss  vss  sky130_fd_pr__nfet_01v8  w=4  l=0.35
Cw_route_19_6  vw_route_19_6  vss  200f
R_bleed_19_6  vw_route_19_6  vss  10000meg
XMN4_r_19_6  vw_route_19_6  we_route  iwrite_route_19_6  vss  sky130_fd_pr__nfet_01v8  w=0.5  l=0.5
X_rhebb_19_6  iwrite_route_19_6  inp_upper_6  ierr_dig_19  vcm_route  vdd vss  hebbian_mult
XMPRED_r_19_7  i_pred_19  vw_route_19_7  vss  vss  sky130_fd_pr__nfet_01v8  w=4  l=0.35
Cw_route_19_7  vw_route_19_7  vss  200f
R_bleed_19_7  vw_route_19_7  vss  10000meg
XMN4_r_19_7  vw_route_19_7  we_route  iwrite_route_19_7  vss  sky130_fd_pr__nfet_01v8  w=0.5  l=0.5
X_rhebb_19_7  iwrite_route_19_7  inp_upper_7  ierr_dig_19  vcm_route  vdd vss  hebbian_mult
XMPRED_r_19_8  i_pred_19  vw_route_19_8  vss  vss  sky130_fd_pr__nfet_01v8  w=4  l=0.35
Cw_route_19_8  vw_route_19_8  vss  200f
R_bleed_19_8  vw_route_19_8  vss  10000meg
XMN4_r_19_8  vw_route_19_8  we_route  iwrite_route_19_8  vss  sky130_fd_pr__nfet_01v8  w=0.5  l=0.5
X_rhebb_19_8  iwrite_route_19_8  inp_upper_8  ierr_dig_19  vcm_route  vdd vss  hebbian_mult
XMPRED_r_19_9  i_pred_19  vw_route_19_9  vss  vss  sky130_fd_pr__nfet_01v8  w=4  l=0.35
Cw_route_19_9  vw_route_19_9  vss  200f
R_bleed_19_9  vw_route_19_9  vss  10000meg
XMN4_r_19_9  vw_route_19_9  we_route  iwrite_route_19_9  vss  sky130_fd_pr__nfet_01v8  w=0.5  l=0.5
X_rhebb_19_9  iwrite_route_19_9  inp_upper_9  ierr_dig_19  vcm_route  vdd vss  hebbian_mult
XMPRED_r_19_10  i_pred_19  vw_route_19_10  vss  vss  sky130_fd_pr__nfet_01v8  w=4  l=0.35
Cw_route_19_10  vw_route_19_10  vss  200f
R_bleed_19_10  vw_route_19_10  vss  10000meg
XMN4_r_19_10  vw_route_19_10  we_route  iwrite_route_19_10  vss  sky130_fd_pr__nfet_01v8  w=0.5  l=0.5
X_rhebb_19_10  iwrite_route_19_10  inp_upper_10  ierr_dig_19  vcm_route  vdd vss  hebbian_mult
XMPRED_r_19_11  i_pred_19  vw_route_19_11  vss  vss  sky130_fd_pr__nfet_01v8  w=4  l=0.35
Cw_route_19_11  vw_route_19_11  vss  200f
R_bleed_19_11  vw_route_19_11  vss  10000meg
XMN4_r_19_11  vw_route_19_11  we_route  iwrite_route_19_11  vss  sky130_fd_pr__nfet_01v8  w=0.5  l=0.5
X_rhebb_19_11  iwrite_route_19_11  inp_upper_11  ierr_dig_19  vcm_route  vdd vss  hebbian_mult
XMPRED_r_19_12  i_pred_19  vw_route_19_12  vss  vss  sky130_fd_pr__nfet_01v8  w=4  l=0.35
Cw_route_19_12  vw_route_19_12  vss  200f
R_bleed_19_12  vw_route_19_12  vss  10000meg
XMN4_r_19_12  vw_route_19_12  we_route  iwrite_route_19_12  vss  sky130_fd_pr__nfet_01v8  w=0.5  l=0.5
X_rhebb_19_12  iwrite_route_19_12  inp_upper_12  ierr_dig_19  vcm_route  vdd vss  hebbian_mult
XMPRED_r_19_13  i_pred_19  vw_route_19_13  vss  vss  sky130_fd_pr__nfet_01v8  w=4  l=0.35
Cw_route_19_13  vw_route_19_13  vss  200f
R_bleed_19_13  vw_route_19_13  vss  10000meg
XMN4_r_19_13  vw_route_19_13  we_route  iwrite_route_19_13  vss  sky130_fd_pr__nfet_01v8  w=0.5  l=0.5
X_rhebb_19_13  iwrite_route_19_13  inp_upper_13  ierr_dig_19  vcm_route  vdd vss  hebbian_mult
XMPRED_r_19_14  i_pred_19  vw_route_19_14  vss  vss  sky130_fd_pr__nfet_01v8  w=4  l=0.35
Cw_route_19_14  vw_route_19_14  vss  200f
R_bleed_19_14  vw_route_19_14  vss  10000meg
XMN4_r_19_14  vw_route_19_14  we_route  iwrite_route_19_14  vss  sky130_fd_pr__nfet_01v8  w=0.5  l=0.5
X_rhebb_19_14  iwrite_route_19_14  inp_upper_14  ierr_dig_19  vcm_route  vdd vss  hebbian_mult
XMPRED_r_19_15  i_pred_19  vw_route_19_15  vss  vss  sky130_fd_pr__nfet_01v8  w=4  l=0.35
Cw_route_19_15  vw_route_19_15  vss  200f
R_bleed_19_15  vw_route_19_15  vss  10000meg
XMN4_r_19_15  vw_route_19_15  we_route  iwrite_route_19_15  vss  sky130_fd_pr__nfet_01v8  w=0.5  l=0.5
X_rhebb_19_15  iwrite_route_19_15  inp_upper_15  ierr_dig_19  vcm_route  vdd vss  hebbian_mult
XMPRED_r_19_16  i_pred_19  vw_route_19_16  vss  vss  sky130_fd_pr__nfet_01v8  w=4  l=0.35
Cw_route_19_16  vw_route_19_16  vss  200f
R_bleed_19_16  vw_route_19_16  vss  10000meg
XMN4_r_19_16  vw_route_19_16  we_route  iwrite_route_19_16  vss  sky130_fd_pr__nfet_01v8  w=0.5  l=0.5
X_rhebb_19_16  iwrite_route_19_16  inp_upper_16  ierr_dig_19  vcm_route  vdd vss  hebbian_mult
XMPRED_r_19_17  i_pred_19  vw_route_19_17  vss  vss  sky130_fd_pr__nfet_01v8  w=4  l=0.35
Cw_route_19_17  vw_route_19_17  vss  200f
R_bleed_19_17  vw_route_19_17  vss  10000meg
XMN4_r_19_17  vw_route_19_17  we_route  iwrite_route_19_17  vss  sky130_fd_pr__nfet_01v8  w=0.5  l=0.5
X_rhebb_19_17  iwrite_route_19_17  inp_upper_17  ierr_dig_19  vcm_route  vdd vss  hebbian_mult
XMPRED_r_19_18  i_pred_19  vw_route_19_18  vss  vss  sky130_fd_pr__nfet_01v8  w=4  l=0.35
Cw_route_19_18  vw_route_19_18  vss  200f
R_bleed_19_18  vw_route_19_18  vss  10000meg
XMN4_r_19_18  vw_route_19_18  we_route  iwrite_route_19_18  vss  sky130_fd_pr__nfet_01v8  w=0.5  l=0.5
X_rhebb_19_18  iwrite_route_19_18  inp_upper_18  ierr_dig_19  vcm_route  vdd vss  hebbian_mult
XMPRED_r_19_19  i_pred_19  vw_route_19_19  vss  vss  sky130_fd_pr__nfet_01v8  w=4  l=0.35
Cw_route_19_19  vw_route_19_19  vss  200f
R_bleed_19_19  vw_route_19_19  vss  10000meg
XMN4_r_19_19  vw_route_19_19  we_route  iwrite_route_19_19  vss  sky130_fd_pr__nfet_01v8  w=0.5  l=0.5
X_rhebb_19_19  iwrite_route_19_19  inp_upper_19  ierr_dig_19  vcm_route  vdd vss  hebbian_mult
XMPRED_r_19_20  i_pred_19  vw_route_19_20  vss  vss  sky130_fd_pr__nfet_01v8  w=4  l=0.35
Cw_route_19_20  vw_route_19_20  vss  200f
R_bleed_19_20  vw_route_19_20  vss  10000meg
XMN4_r_19_20  vw_route_19_20  we_route  iwrite_route_19_20  vss  sky130_fd_pr__nfet_01v8  w=0.5  l=0.5
X_rhebb_19_20  iwrite_route_19_20  inp_upper_20  ierr_dig_19  vcm_route  vdd vss  hebbian_mult
XMPRED_r_19_21  i_pred_19  vw_route_19_21  vss  vss  sky130_fd_pr__nfet_01v8  w=4  l=0.35
Cw_route_19_21  vw_route_19_21  vss  200f
R_bleed_19_21  vw_route_19_21  vss  10000meg
XMN4_r_19_21  vw_route_19_21  we_route  iwrite_route_19_21  vss  sky130_fd_pr__nfet_01v8  w=0.5  l=0.5
X_rhebb_19_21  iwrite_route_19_21  inp_upper_21  ierr_dig_19  vcm_route  vdd vss  hebbian_mult
XMPRED_r_19_22  i_pred_19  vw_route_19_22  vss  vss  sky130_fd_pr__nfet_01v8  w=4  l=0.35
Cw_route_19_22  vw_route_19_22  vss  200f
R_bleed_19_22  vw_route_19_22  vss  10000meg
XMN4_r_19_22  vw_route_19_22  we_route  iwrite_route_19_22  vss  sky130_fd_pr__nfet_01v8  w=0.5  l=0.5
X_rhebb_19_22  iwrite_route_19_22  inp_upper_22  ierr_dig_19  vcm_route  vdd vss  hebbian_mult
XMPRED_r_19_23  i_pred_19  vw_route_19_23  vss  vss  sky130_fd_pr__nfet_01v8  w=4  l=0.35
Cw_route_19_23  vw_route_19_23  vss  200f
R_bleed_19_23  vw_route_19_23  vss  10000meg
XMN4_r_19_23  vw_route_19_23  we_route  iwrite_route_19_23  vss  sky130_fd_pr__nfet_01v8  w=0.5  l=0.5
X_rhebb_19_23  iwrite_route_19_23  inp_upper_23  ierr_dig_19  vcm_route  vdd vss  hebbian_mult
XMPRED_r_19_24  i_pred_19  vw_route_19_24  vss  vss  sky130_fd_pr__nfet_01v8  w=4  l=0.35
Cw_route_19_24  vw_route_19_24  vss  200f
R_bleed_19_24  vw_route_19_24  vss  10000meg
XMN4_r_19_24  vw_route_19_24  we_route  iwrite_route_19_24  vss  sky130_fd_pr__nfet_01v8  w=0.5  l=0.5
X_rhebb_19_24  iwrite_route_19_24  inp_upper_24  ierr_dig_19  vcm_route  vdd vss  hebbian_mult
XMPRED_r_19_25  i_pred_19  vw_route_19_25  vss  vss  sky130_fd_pr__nfet_01v8  w=4  l=0.35
Cw_route_19_25  vw_route_19_25  vss  200f
R_bleed_19_25  vw_route_19_25  vss  10000meg
XMN4_r_19_25  vw_route_19_25  we_route  iwrite_route_19_25  vss  sky130_fd_pr__nfet_01v8  w=0.5  l=0.5
X_rhebb_19_25  iwrite_route_19_25  inp_upper_25  ierr_dig_19  vcm_route  vdd vss  hebbian_mult
XMPRED_r_19_26  i_pred_19  vw_route_19_26  vss  vss  sky130_fd_pr__nfet_01v8  w=4  l=0.35
Cw_route_19_26  vw_route_19_26  vss  200f
R_bleed_19_26  vw_route_19_26  vss  10000meg
XMN4_r_19_26  vw_route_19_26  we_route  iwrite_route_19_26  vss  sky130_fd_pr__nfet_01v8  w=0.5  l=0.5
X_rhebb_19_26  iwrite_route_19_26  inp_upper_26  ierr_dig_19  vcm_route  vdd vss  hebbian_mult
XMPRED_r_19_27  i_pred_19  vw_route_19_27  vss  vss  sky130_fd_pr__nfet_01v8  w=4  l=0.35
Cw_route_19_27  vw_route_19_27  vss  200f
R_bleed_19_27  vw_route_19_27  vss  10000meg
XMN4_r_19_27  vw_route_19_27  we_route  iwrite_route_19_27  vss  sky130_fd_pr__nfet_01v8  w=0.5  l=0.5
X_rhebb_19_27  iwrite_route_19_27  inp_upper_27  ierr_dig_19  vcm_route  vdd vss  hebbian_mult
XMPRED_r_19_28  i_pred_19  vw_route_19_28  vss  vss  sky130_fd_pr__nfet_01v8  w=4  l=0.35
Cw_route_19_28  vw_route_19_28  vss  200f
R_bleed_19_28  vw_route_19_28  vss  10000meg
XMN4_r_19_28  vw_route_19_28  we_route  iwrite_route_19_28  vss  sky130_fd_pr__nfet_01v8  w=0.5  l=0.5
X_rhebb_19_28  iwrite_route_19_28  inp_upper_28  ierr_dig_19  vcm_route  vdd vss  hebbian_mult
XMPRED_r_19_29  i_pred_19  vw_route_19_29  vss  vss  sky130_fd_pr__nfet_01v8  w=4  l=0.35
Cw_route_19_29  vw_route_19_29  vss  200f
R_bleed_19_29  vw_route_19_29  vss  10000meg
XMN4_r_19_29  vw_route_19_29  we_route  iwrite_route_19_29  vss  sky130_fd_pr__nfet_01v8  w=0.5  l=0.5
X_rhebb_19_29  iwrite_route_19_29  inp_upper_29  ierr_dig_19  vcm_route  vdd vss  hebbian_mult
XMPRED_r_19_30  i_pred_19  vw_route_19_30  vss  vss  sky130_fd_pr__nfet_01v8  w=4  l=0.35
Cw_route_19_30  vw_route_19_30  vss  200f
R_bleed_19_30  vw_route_19_30  vss  10000meg
XMN4_r_19_30  vw_route_19_30  we_route  iwrite_route_19_30  vss  sky130_fd_pr__nfet_01v8  w=0.5  l=0.5
X_rhebb_19_30  iwrite_route_19_30  inp_upper_30  ierr_dig_19  vcm_route  vdd vss  hebbian_mult
XMPRED_r_19_31  i_pred_19  vw_route_19_31  vss  vss  sky130_fd_pr__nfet_01v8  w=4  l=0.35
Cw_route_19_31  vw_route_19_31  vss  200f
R_bleed_19_31  vw_route_19_31  vss  10000meg
XMN4_r_19_31  vw_route_19_31  we_route  iwrite_route_19_31  vss  sky130_fd_pr__nfet_01v8  w=0.5  l=0.5
X_rhebb_19_31  iwrite_route_19_31  inp_upper_31  ierr_dig_19  vcm_route  vdd vss  hebbian_mult

* ── Destination row 20 ── 32 source connections ──────────────────────────
XMPRED_r_20_0  i_pred_20  vw_route_20_0  vss  vss  sky130_fd_pr__nfet_01v8  w=4  l=0.35
Cw_route_20_0  vw_route_20_0  vss  200f
R_bleed_20_0  vw_route_20_0  vss  10000meg
XMN4_r_20_0  vw_route_20_0  we_route  iwrite_route_20_0  vss  sky130_fd_pr__nfet_01v8  w=0.5  l=0.5
X_rhebb_20_0  iwrite_route_20_0  inp_upper_0  ierr_dig_20  vcm_route  vdd vss  hebbian_mult
XMPRED_r_20_1  i_pred_20  vw_route_20_1  vss  vss  sky130_fd_pr__nfet_01v8  w=4  l=0.35
Cw_route_20_1  vw_route_20_1  vss  200f
R_bleed_20_1  vw_route_20_1  vss  10000meg
XMN4_r_20_1  vw_route_20_1  we_route  iwrite_route_20_1  vss  sky130_fd_pr__nfet_01v8  w=0.5  l=0.5
X_rhebb_20_1  iwrite_route_20_1  inp_upper_1  ierr_dig_20  vcm_route  vdd vss  hebbian_mult
XMPRED_r_20_2  i_pred_20  vw_route_20_2  vss  vss  sky130_fd_pr__nfet_01v8  w=4  l=0.35
Cw_route_20_2  vw_route_20_2  vss  200f
R_bleed_20_2  vw_route_20_2  vss  10000meg
XMN4_r_20_2  vw_route_20_2  we_route  iwrite_route_20_2  vss  sky130_fd_pr__nfet_01v8  w=0.5  l=0.5
X_rhebb_20_2  iwrite_route_20_2  inp_upper_2  ierr_dig_20  vcm_route  vdd vss  hebbian_mult
XMPRED_r_20_3  i_pred_20  vw_route_20_3  vss  vss  sky130_fd_pr__nfet_01v8  w=4  l=0.35
Cw_route_20_3  vw_route_20_3  vss  200f
R_bleed_20_3  vw_route_20_3  vss  10000meg
XMN4_r_20_3  vw_route_20_3  we_route  iwrite_route_20_3  vss  sky130_fd_pr__nfet_01v8  w=0.5  l=0.5
X_rhebb_20_3  iwrite_route_20_3  inp_upper_3  ierr_dig_20  vcm_route  vdd vss  hebbian_mult
XMPRED_r_20_4  i_pred_20  vw_route_20_4  vss  vss  sky130_fd_pr__nfet_01v8  w=4  l=0.35
Cw_route_20_4  vw_route_20_4  vss  200f
R_bleed_20_4  vw_route_20_4  vss  10000meg
XMN4_r_20_4  vw_route_20_4  we_route  iwrite_route_20_4  vss  sky130_fd_pr__nfet_01v8  w=0.5  l=0.5
X_rhebb_20_4  iwrite_route_20_4  inp_upper_4  ierr_dig_20  vcm_route  vdd vss  hebbian_mult
XMPRED_r_20_5  i_pred_20  vw_route_20_5  vss  vss  sky130_fd_pr__nfet_01v8  w=4  l=0.35
Cw_route_20_5  vw_route_20_5  vss  200f
R_bleed_20_5  vw_route_20_5  vss  10000meg
XMN4_r_20_5  vw_route_20_5  we_route  iwrite_route_20_5  vss  sky130_fd_pr__nfet_01v8  w=0.5  l=0.5
X_rhebb_20_5  iwrite_route_20_5  inp_upper_5  ierr_dig_20  vcm_route  vdd vss  hebbian_mult
XMPRED_r_20_6  i_pred_20  vw_route_20_6  vss  vss  sky130_fd_pr__nfet_01v8  w=4  l=0.35
Cw_route_20_6  vw_route_20_6  vss  200f
R_bleed_20_6  vw_route_20_6  vss  10000meg
XMN4_r_20_6  vw_route_20_6  we_route  iwrite_route_20_6  vss  sky130_fd_pr__nfet_01v8  w=0.5  l=0.5
X_rhebb_20_6  iwrite_route_20_6  inp_upper_6  ierr_dig_20  vcm_route  vdd vss  hebbian_mult
XMPRED_r_20_7  i_pred_20  vw_route_20_7  vss  vss  sky130_fd_pr__nfet_01v8  w=4  l=0.35
Cw_route_20_7  vw_route_20_7  vss  200f
R_bleed_20_7  vw_route_20_7  vss  10000meg
XMN4_r_20_7  vw_route_20_7  we_route  iwrite_route_20_7  vss  sky130_fd_pr__nfet_01v8  w=0.5  l=0.5
X_rhebb_20_7  iwrite_route_20_7  inp_upper_7  ierr_dig_20  vcm_route  vdd vss  hebbian_mult
XMPRED_r_20_8  i_pred_20  vw_route_20_8  vss  vss  sky130_fd_pr__nfet_01v8  w=4  l=0.35
Cw_route_20_8  vw_route_20_8  vss  200f
R_bleed_20_8  vw_route_20_8  vss  10000meg
XMN4_r_20_8  vw_route_20_8  we_route  iwrite_route_20_8  vss  sky130_fd_pr__nfet_01v8  w=0.5  l=0.5
X_rhebb_20_8  iwrite_route_20_8  inp_upper_8  ierr_dig_20  vcm_route  vdd vss  hebbian_mult
XMPRED_r_20_9  i_pred_20  vw_route_20_9  vss  vss  sky130_fd_pr__nfet_01v8  w=4  l=0.35
Cw_route_20_9  vw_route_20_9  vss  200f
R_bleed_20_9  vw_route_20_9  vss  10000meg
XMN4_r_20_9  vw_route_20_9  we_route  iwrite_route_20_9  vss  sky130_fd_pr__nfet_01v8  w=0.5  l=0.5
X_rhebb_20_9  iwrite_route_20_9  inp_upper_9  ierr_dig_20  vcm_route  vdd vss  hebbian_mult
XMPRED_r_20_10  i_pred_20  vw_route_20_10  vss  vss  sky130_fd_pr__nfet_01v8  w=4  l=0.35
Cw_route_20_10  vw_route_20_10  vss  200f
R_bleed_20_10  vw_route_20_10  vss  10000meg
XMN4_r_20_10  vw_route_20_10  we_route  iwrite_route_20_10  vss  sky130_fd_pr__nfet_01v8  w=0.5  l=0.5
X_rhebb_20_10  iwrite_route_20_10  inp_upper_10  ierr_dig_20  vcm_route  vdd vss  hebbian_mult
XMPRED_r_20_11  i_pred_20  vw_route_20_11  vss  vss  sky130_fd_pr__nfet_01v8  w=4  l=0.35
Cw_route_20_11  vw_route_20_11  vss  200f
R_bleed_20_11  vw_route_20_11  vss  10000meg
XMN4_r_20_11  vw_route_20_11  we_route  iwrite_route_20_11  vss  sky130_fd_pr__nfet_01v8  w=0.5  l=0.5
X_rhebb_20_11  iwrite_route_20_11  inp_upper_11  ierr_dig_20  vcm_route  vdd vss  hebbian_mult
XMPRED_r_20_12  i_pred_20  vw_route_20_12  vss  vss  sky130_fd_pr__nfet_01v8  w=4  l=0.35
Cw_route_20_12  vw_route_20_12  vss  200f
R_bleed_20_12  vw_route_20_12  vss  10000meg
XMN4_r_20_12  vw_route_20_12  we_route  iwrite_route_20_12  vss  sky130_fd_pr__nfet_01v8  w=0.5  l=0.5
X_rhebb_20_12  iwrite_route_20_12  inp_upper_12  ierr_dig_20  vcm_route  vdd vss  hebbian_mult
XMPRED_r_20_13  i_pred_20  vw_route_20_13  vss  vss  sky130_fd_pr__nfet_01v8  w=4  l=0.35
Cw_route_20_13  vw_route_20_13  vss  200f
R_bleed_20_13  vw_route_20_13  vss  10000meg
XMN4_r_20_13  vw_route_20_13  we_route  iwrite_route_20_13  vss  sky130_fd_pr__nfet_01v8  w=0.5  l=0.5
X_rhebb_20_13  iwrite_route_20_13  inp_upper_13  ierr_dig_20  vcm_route  vdd vss  hebbian_mult
XMPRED_r_20_14  i_pred_20  vw_route_20_14  vss  vss  sky130_fd_pr__nfet_01v8  w=4  l=0.35
Cw_route_20_14  vw_route_20_14  vss  200f
R_bleed_20_14  vw_route_20_14  vss  10000meg
XMN4_r_20_14  vw_route_20_14  we_route  iwrite_route_20_14  vss  sky130_fd_pr__nfet_01v8  w=0.5  l=0.5
X_rhebb_20_14  iwrite_route_20_14  inp_upper_14  ierr_dig_20  vcm_route  vdd vss  hebbian_mult
XMPRED_r_20_15  i_pred_20  vw_route_20_15  vss  vss  sky130_fd_pr__nfet_01v8  w=4  l=0.35
Cw_route_20_15  vw_route_20_15  vss  200f
R_bleed_20_15  vw_route_20_15  vss  10000meg
XMN4_r_20_15  vw_route_20_15  we_route  iwrite_route_20_15  vss  sky130_fd_pr__nfet_01v8  w=0.5  l=0.5
X_rhebb_20_15  iwrite_route_20_15  inp_upper_15  ierr_dig_20  vcm_route  vdd vss  hebbian_mult
XMPRED_r_20_16  i_pred_20  vw_route_20_16  vss  vss  sky130_fd_pr__nfet_01v8  w=4  l=0.35
Cw_route_20_16  vw_route_20_16  vss  200f
R_bleed_20_16  vw_route_20_16  vss  10000meg
XMN4_r_20_16  vw_route_20_16  we_route  iwrite_route_20_16  vss  sky130_fd_pr__nfet_01v8  w=0.5  l=0.5
X_rhebb_20_16  iwrite_route_20_16  inp_upper_16  ierr_dig_20  vcm_route  vdd vss  hebbian_mult
XMPRED_r_20_17  i_pred_20  vw_route_20_17  vss  vss  sky130_fd_pr__nfet_01v8  w=4  l=0.35
Cw_route_20_17  vw_route_20_17  vss  200f
R_bleed_20_17  vw_route_20_17  vss  10000meg
XMN4_r_20_17  vw_route_20_17  we_route  iwrite_route_20_17  vss  sky130_fd_pr__nfet_01v8  w=0.5  l=0.5
X_rhebb_20_17  iwrite_route_20_17  inp_upper_17  ierr_dig_20  vcm_route  vdd vss  hebbian_mult
XMPRED_r_20_18  i_pred_20  vw_route_20_18  vss  vss  sky130_fd_pr__nfet_01v8  w=4  l=0.35
Cw_route_20_18  vw_route_20_18  vss  200f
R_bleed_20_18  vw_route_20_18  vss  10000meg
XMN4_r_20_18  vw_route_20_18  we_route  iwrite_route_20_18  vss  sky130_fd_pr__nfet_01v8  w=0.5  l=0.5
X_rhebb_20_18  iwrite_route_20_18  inp_upper_18  ierr_dig_20  vcm_route  vdd vss  hebbian_mult
XMPRED_r_20_19  i_pred_20  vw_route_20_19  vss  vss  sky130_fd_pr__nfet_01v8  w=4  l=0.35
Cw_route_20_19  vw_route_20_19  vss  200f
R_bleed_20_19  vw_route_20_19  vss  10000meg
XMN4_r_20_19  vw_route_20_19  we_route  iwrite_route_20_19  vss  sky130_fd_pr__nfet_01v8  w=0.5  l=0.5
X_rhebb_20_19  iwrite_route_20_19  inp_upper_19  ierr_dig_20  vcm_route  vdd vss  hebbian_mult
XMPRED_r_20_20  i_pred_20  vw_route_20_20  vss  vss  sky130_fd_pr__nfet_01v8  w=4  l=0.35
Cw_route_20_20  vw_route_20_20  vss  200f
R_bleed_20_20  vw_route_20_20  vss  10000meg
XMN4_r_20_20  vw_route_20_20  we_route  iwrite_route_20_20  vss  sky130_fd_pr__nfet_01v8  w=0.5  l=0.5
X_rhebb_20_20  iwrite_route_20_20  inp_upper_20  ierr_dig_20  vcm_route  vdd vss  hebbian_mult
XMPRED_r_20_21  i_pred_20  vw_route_20_21  vss  vss  sky130_fd_pr__nfet_01v8  w=4  l=0.35
Cw_route_20_21  vw_route_20_21  vss  200f
R_bleed_20_21  vw_route_20_21  vss  10000meg
XMN4_r_20_21  vw_route_20_21  we_route  iwrite_route_20_21  vss  sky130_fd_pr__nfet_01v8  w=0.5  l=0.5
X_rhebb_20_21  iwrite_route_20_21  inp_upper_21  ierr_dig_20  vcm_route  vdd vss  hebbian_mult
XMPRED_r_20_22  i_pred_20  vw_route_20_22  vss  vss  sky130_fd_pr__nfet_01v8  w=4  l=0.35
Cw_route_20_22  vw_route_20_22  vss  200f
R_bleed_20_22  vw_route_20_22  vss  10000meg
XMN4_r_20_22  vw_route_20_22  we_route  iwrite_route_20_22  vss  sky130_fd_pr__nfet_01v8  w=0.5  l=0.5
X_rhebb_20_22  iwrite_route_20_22  inp_upper_22  ierr_dig_20  vcm_route  vdd vss  hebbian_mult
XMPRED_r_20_23  i_pred_20  vw_route_20_23  vss  vss  sky130_fd_pr__nfet_01v8  w=4  l=0.35
Cw_route_20_23  vw_route_20_23  vss  200f
R_bleed_20_23  vw_route_20_23  vss  10000meg
XMN4_r_20_23  vw_route_20_23  we_route  iwrite_route_20_23  vss  sky130_fd_pr__nfet_01v8  w=0.5  l=0.5
X_rhebb_20_23  iwrite_route_20_23  inp_upper_23  ierr_dig_20  vcm_route  vdd vss  hebbian_mult
XMPRED_r_20_24  i_pred_20  vw_route_20_24  vss  vss  sky130_fd_pr__nfet_01v8  w=4  l=0.35
Cw_route_20_24  vw_route_20_24  vss  200f
R_bleed_20_24  vw_route_20_24  vss  10000meg
XMN4_r_20_24  vw_route_20_24  we_route  iwrite_route_20_24  vss  sky130_fd_pr__nfet_01v8  w=0.5  l=0.5
X_rhebb_20_24  iwrite_route_20_24  inp_upper_24  ierr_dig_20  vcm_route  vdd vss  hebbian_mult
XMPRED_r_20_25  i_pred_20  vw_route_20_25  vss  vss  sky130_fd_pr__nfet_01v8  w=4  l=0.35
Cw_route_20_25  vw_route_20_25  vss  200f
R_bleed_20_25  vw_route_20_25  vss  10000meg
XMN4_r_20_25  vw_route_20_25  we_route  iwrite_route_20_25  vss  sky130_fd_pr__nfet_01v8  w=0.5  l=0.5
X_rhebb_20_25  iwrite_route_20_25  inp_upper_25  ierr_dig_20  vcm_route  vdd vss  hebbian_mult
XMPRED_r_20_26  i_pred_20  vw_route_20_26  vss  vss  sky130_fd_pr__nfet_01v8  w=4  l=0.35
Cw_route_20_26  vw_route_20_26  vss  200f
R_bleed_20_26  vw_route_20_26  vss  10000meg
XMN4_r_20_26  vw_route_20_26  we_route  iwrite_route_20_26  vss  sky130_fd_pr__nfet_01v8  w=0.5  l=0.5
X_rhebb_20_26  iwrite_route_20_26  inp_upper_26  ierr_dig_20  vcm_route  vdd vss  hebbian_mult
XMPRED_r_20_27  i_pred_20  vw_route_20_27  vss  vss  sky130_fd_pr__nfet_01v8  w=4  l=0.35
Cw_route_20_27  vw_route_20_27  vss  200f
R_bleed_20_27  vw_route_20_27  vss  10000meg
XMN4_r_20_27  vw_route_20_27  we_route  iwrite_route_20_27  vss  sky130_fd_pr__nfet_01v8  w=0.5  l=0.5
X_rhebb_20_27  iwrite_route_20_27  inp_upper_27  ierr_dig_20  vcm_route  vdd vss  hebbian_mult
XMPRED_r_20_28  i_pred_20  vw_route_20_28  vss  vss  sky130_fd_pr__nfet_01v8  w=4  l=0.35
Cw_route_20_28  vw_route_20_28  vss  200f
R_bleed_20_28  vw_route_20_28  vss  10000meg
XMN4_r_20_28  vw_route_20_28  we_route  iwrite_route_20_28  vss  sky130_fd_pr__nfet_01v8  w=0.5  l=0.5
X_rhebb_20_28  iwrite_route_20_28  inp_upper_28  ierr_dig_20  vcm_route  vdd vss  hebbian_mult
XMPRED_r_20_29  i_pred_20  vw_route_20_29  vss  vss  sky130_fd_pr__nfet_01v8  w=4  l=0.35
Cw_route_20_29  vw_route_20_29  vss  200f
R_bleed_20_29  vw_route_20_29  vss  10000meg
XMN4_r_20_29  vw_route_20_29  we_route  iwrite_route_20_29  vss  sky130_fd_pr__nfet_01v8  w=0.5  l=0.5
X_rhebb_20_29  iwrite_route_20_29  inp_upper_29  ierr_dig_20  vcm_route  vdd vss  hebbian_mult
XMPRED_r_20_30  i_pred_20  vw_route_20_30  vss  vss  sky130_fd_pr__nfet_01v8  w=4  l=0.35
Cw_route_20_30  vw_route_20_30  vss  200f
R_bleed_20_30  vw_route_20_30  vss  10000meg
XMN4_r_20_30  vw_route_20_30  we_route  iwrite_route_20_30  vss  sky130_fd_pr__nfet_01v8  w=0.5  l=0.5
X_rhebb_20_30  iwrite_route_20_30  inp_upper_30  ierr_dig_20  vcm_route  vdd vss  hebbian_mult
XMPRED_r_20_31  i_pred_20  vw_route_20_31  vss  vss  sky130_fd_pr__nfet_01v8  w=4  l=0.35
Cw_route_20_31  vw_route_20_31  vss  200f
R_bleed_20_31  vw_route_20_31  vss  10000meg
XMN4_r_20_31  vw_route_20_31  we_route  iwrite_route_20_31  vss  sky130_fd_pr__nfet_01v8  w=0.5  l=0.5
X_rhebb_20_31  iwrite_route_20_31  inp_upper_31  ierr_dig_20  vcm_route  vdd vss  hebbian_mult

* ── Destination row 21 ── 32 source connections ──────────────────────────
XMPRED_r_21_0  i_pred_21  vw_route_21_0  vss  vss  sky130_fd_pr__nfet_01v8  w=4  l=0.35
Cw_route_21_0  vw_route_21_0  vss  200f
R_bleed_21_0  vw_route_21_0  vss  10000meg
XMN4_r_21_0  vw_route_21_0  we_route  iwrite_route_21_0  vss  sky130_fd_pr__nfet_01v8  w=0.5  l=0.5
X_rhebb_21_0  iwrite_route_21_0  inp_upper_0  ierr_dig_21  vcm_route  vdd vss  hebbian_mult
XMPRED_r_21_1  i_pred_21  vw_route_21_1  vss  vss  sky130_fd_pr__nfet_01v8  w=4  l=0.35
Cw_route_21_1  vw_route_21_1  vss  200f
R_bleed_21_1  vw_route_21_1  vss  10000meg
XMN4_r_21_1  vw_route_21_1  we_route  iwrite_route_21_1  vss  sky130_fd_pr__nfet_01v8  w=0.5  l=0.5
X_rhebb_21_1  iwrite_route_21_1  inp_upper_1  ierr_dig_21  vcm_route  vdd vss  hebbian_mult
XMPRED_r_21_2  i_pred_21  vw_route_21_2  vss  vss  sky130_fd_pr__nfet_01v8  w=4  l=0.35
Cw_route_21_2  vw_route_21_2  vss  200f
R_bleed_21_2  vw_route_21_2  vss  10000meg
XMN4_r_21_2  vw_route_21_2  we_route  iwrite_route_21_2  vss  sky130_fd_pr__nfet_01v8  w=0.5  l=0.5
X_rhebb_21_2  iwrite_route_21_2  inp_upper_2  ierr_dig_21  vcm_route  vdd vss  hebbian_mult
XMPRED_r_21_3  i_pred_21  vw_route_21_3  vss  vss  sky130_fd_pr__nfet_01v8  w=4  l=0.35
Cw_route_21_3  vw_route_21_3  vss  200f
R_bleed_21_3  vw_route_21_3  vss  10000meg
XMN4_r_21_3  vw_route_21_3  we_route  iwrite_route_21_3  vss  sky130_fd_pr__nfet_01v8  w=0.5  l=0.5
X_rhebb_21_3  iwrite_route_21_3  inp_upper_3  ierr_dig_21  vcm_route  vdd vss  hebbian_mult
XMPRED_r_21_4  i_pred_21  vw_route_21_4  vss  vss  sky130_fd_pr__nfet_01v8  w=4  l=0.35
Cw_route_21_4  vw_route_21_4  vss  200f
R_bleed_21_4  vw_route_21_4  vss  10000meg
XMN4_r_21_4  vw_route_21_4  we_route  iwrite_route_21_4  vss  sky130_fd_pr__nfet_01v8  w=0.5  l=0.5
X_rhebb_21_4  iwrite_route_21_4  inp_upper_4  ierr_dig_21  vcm_route  vdd vss  hebbian_mult
XMPRED_r_21_5  i_pred_21  vw_route_21_5  vss  vss  sky130_fd_pr__nfet_01v8  w=4  l=0.35
Cw_route_21_5  vw_route_21_5  vss  200f
R_bleed_21_5  vw_route_21_5  vss  10000meg
XMN4_r_21_5  vw_route_21_5  we_route  iwrite_route_21_5  vss  sky130_fd_pr__nfet_01v8  w=0.5  l=0.5
X_rhebb_21_5  iwrite_route_21_5  inp_upper_5  ierr_dig_21  vcm_route  vdd vss  hebbian_mult
XMPRED_r_21_6  i_pred_21  vw_route_21_6  vss  vss  sky130_fd_pr__nfet_01v8  w=4  l=0.35
Cw_route_21_6  vw_route_21_6  vss  200f
R_bleed_21_6  vw_route_21_6  vss  10000meg
XMN4_r_21_6  vw_route_21_6  we_route  iwrite_route_21_6  vss  sky130_fd_pr__nfet_01v8  w=0.5  l=0.5
X_rhebb_21_6  iwrite_route_21_6  inp_upper_6  ierr_dig_21  vcm_route  vdd vss  hebbian_mult
XMPRED_r_21_7  i_pred_21  vw_route_21_7  vss  vss  sky130_fd_pr__nfet_01v8  w=4  l=0.35
Cw_route_21_7  vw_route_21_7  vss  200f
R_bleed_21_7  vw_route_21_7  vss  10000meg
XMN4_r_21_7  vw_route_21_7  we_route  iwrite_route_21_7  vss  sky130_fd_pr__nfet_01v8  w=0.5  l=0.5
X_rhebb_21_7  iwrite_route_21_7  inp_upper_7  ierr_dig_21  vcm_route  vdd vss  hebbian_mult
XMPRED_r_21_8  i_pred_21  vw_route_21_8  vss  vss  sky130_fd_pr__nfet_01v8  w=4  l=0.35
Cw_route_21_8  vw_route_21_8  vss  200f
R_bleed_21_8  vw_route_21_8  vss  10000meg
XMN4_r_21_8  vw_route_21_8  we_route  iwrite_route_21_8  vss  sky130_fd_pr__nfet_01v8  w=0.5  l=0.5
X_rhebb_21_8  iwrite_route_21_8  inp_upper_8  ierr_dig_21  vcm_route  vdd vss  hebbian_mult
XMPRED_r_21_9  i_pred_21  vw_route_21_9  vss  vss  sky130_fd_pr__nfet_01v8  w=4  l=0.35
Cw_route_21_9  vw_route_21_9  vss  200f
R_bleed_21_9  vw_route_21_9  vss  10000meg
XMN4_r_21_9  vw_route_21_9  we_route  iwrite_route_21_9  vss  sky130_fd_pr__nfet_01v8  w=0.5  l=0.5
X_rhebb_21_9  iwrite_route_21_9  inp_upper_9  ierr_dig_21  vcm_route  vdd vss  hebbian_mult
XMPRED_r_21_10  i_pred_21  vw_route_21_10  vss  vss  sky130_fd_pr__nfet_01v8  w=4  l=0.35
Cw_route_21_10  vw_route_21_10  vss  200f
R_bleed_21_10  vw_route_21_10  vss  10000meg
XMN4_r_21_10  vw_route_21_10  we_route  iwrite_route_21_10  vss  sky130_fd_pr__nfet_01v8  w=0.5  l=0.5
X_rhebb_21_10  iwrite_route_21_10  inp_upper_10  ierr_dig_21  vcm_route  vdd vss  hebbian_mult
XMPRED_r_21_11  i_pred_21  vw_route_21_11  vss  vss  sky130_fd_pr__nfet_01v8  w=4  l=0.35
Cw_route_21_11  vw_route_21_11  vss  200f
R_bleed_21_11  vw_route_21_11  vss  10000meg
XMN4_r_21_11  vw_route_21_11  we_route  iwrite_route_21_11  vss  sky130_fd_pr__nfet_01v8  w=0.5  l=0.5
X_rhebb_21_11  iwrite_route_21_11  inp_upper_11  ierr_dig_21  vcm_route  vdd vss  hebbian_mult
XMPRED_r_21_12  i_pred_21  vw_route_21_12  vss  vss  sky130_fd_pr__nfet_01v8  w=4  l=0.35
Cw_route_21_12  vw_route_21_12  vss  200f
R_bleed_21_12  vw_route_21_12  vss  10000meg
XMN4_r_21_12  vw_route_21_12  we_route  iwrite_route_21_12  vss  sky130_fd_pr__nfet_01v8  w=0.5  l=0.5
X_rhebb_21_12  iwrite_route_21_12  inp_upper_12  ierr_dig_21  vcm_route  vdd vss  hebbian_mult
XMPRED_r_21_13  i_pred_21  vw_route_21_13  vss  vss  sky130_fd_pr__nfet_01v8  w=4  l=0.35
Cw_route_21_13  vw_route_21_13  vss  200f
R_bleed_21_13  vw_route_21_13  vss  10000meg
XMN4_r_21_13  vw_route_21_13  we_route  iwrite_route_21_13  vss  sky130_fd_pr__nfet_01v8  w=0.5  l=0.5
X_rhebb_21_13  iwrite_route_21_13  inp_upper_13  ierr_dig_21  vcm_route  vdd vss  hebbian_mult
XMPRED_r_21_14  i_pred_21  vw_route_21_14  vss  vss  sky130_fd_pr__nfet_01v8  w=4  l=0.35
Cw_route_21_14  vw_route_21_14  vss  200f
R_bleed_21_14  vw_route_21_14  vss  10000meg
XMN4_r_21_14  vw_route_21_14  we_route  iwrite_route_21_14  vss  sky130_fd_pr__nfet_01v8  w=0.5  l=0.5
X_rhebb_21_14  iwrite_route_21_14  inp_upper_14  ierr_dig_21  vcm_route  vdd vss  hebbian_mult
XMPRED_r_21_15  i_pred_21  vw_route_21_15  vss  vss  sky130_fd_pr__nfet_01v8  w=4  l=0.35
Cw_route_21_15  vw_route_21_15  vss  200f
R_bleed_21_15  vw_route_21_15  vss  10000meg
XMN4_r_21_15  vw_route_21_15  we_route  iwrite_route_21_15  vss  sky130_fd_pr__nfet_01v8  w=0.5  l=0.5
X_rhebb_21_15  iwrite_route_21_15  inp_upper_15  ierr_dig_21  vcm_route  vdd vss  hebbian_mult
XMPRED_r_21_16  i_pred_21  vw_route_21_16  vss  vss  sky130_fd_pr__nfet_01v8  w=4  l=0.35
Cw_route_21_16  vw_route_21_16  vss  200f
R_bleed_21_16  vw_route_21_16  vss  10000meg
XMN4_r_21_16  vw_route_21_16  we_route  iwrite_route_21_16  vss  sky130_fd_pr__nfet_01v8  w=0.5  l=0.5
X_rhebb_21_16  iwrite_route_21_16  inp_upper_16  ierr_dig_21  vcm_route  vdd vss  hebbian_mult
XMPRED_r_21_17  i_pred_21  vw_route_21_17  vss  vss  sky130_fd_pr__nfet_01v8  w=4  l=0.35
Cw_route_21_17  vw_route_21_17  vss  200f
R_bleed_21_17  vw_route_21_17  vss  10000meg
XMN4_r_21_17  vw_route_21_17  we_route  iwrite_route_21_17  vss  sky130_fd_pr__nfet_01v8  w=0.5  l=0.5
X_rhebb_21_17  iwrite_route_21_17  inp_upper_17  ierr_dig_21  vcm_route  vdd vss  hebbian_mult
XMPRED_r_21_18  i_pred_21  vw_route_21_18  vss  vss  sky130_fd_pr__nfet_01v8  w=4  l=0.35
Cw_route_21_18  vw_route_21_18  vss  200f
R_bleed_21_18  vw_route_21_18  vss  10000meg
XMN4_r_21_18  vw_route_21_18  we_route  iwrite_route_21_18  vss  sky130_fd_pr__nfet_01v8  w=0.5  l=0.5
X_rhebb_21_18  iwrite_route_21_18  inp_upper_18  ierr_dig_21  vcm_route  vdd vss  hebbian_mult
XMPRED_r_21_19  i_pred_21  vw_route_21_19  vss  vss  sky130_fd_pr__nfet_01v8  w=4  l=0.35
Cw_route_21_19  vw_route_21_19  vss  200f
R_bleed_21_19  vw_route_21_19  vss  10000meg
XMN4_r_21_19  vw_route_21_19  we_route  iwrite_route_21_19  vss  sky130_fd_pr__nfet_01v8  w=0.5  l=0.5
X_rhebb_21_19  iwrite_route_21_19  inp_upper_19  ierr_dig_21  vcm_route  vdd vss  hebbian_mult
XMPRED_r_21_20  i_pred_21  vw_route_21_20  vss  vss  sky130_fd_pr__nfet_01v8  w=4  l=0.35
Cw_route_21_20  vw_route_21_20  vss  200f
R_bleed_21_20  vw_route_21_20  vss  10000meg
XMN4_r_21_20  vw_route_21_20  we_route  iwrite_route_21_20  vss  sky130_fd_pr__nfet_01v8  w=0.5  l=0.5
X_rhebb_21_20  iwrite_route_21_20  inp_upper_20  ierr_dig_21  vcm_route  vdd vss  hebbian_mult
XMPRED_r_21_21  i_pred_21  vw_route_21_21  vss  vss  sky130_fd_pr__nfet_01v8  w=4  l=0.35
Cw_route_21_21  vw_route_21_21  vss  200f
R_bleed_21_21  vw_route_21_21  vss  10000meg
XMN4_r_21_21  vw_route_21_21  we_route  iwrite_route_21_21  vss  sky130_fd_pr__nfet_01v8  w=0.5  l=0.5
X_rhebb_21_21  iwrite_route_21_21  inp_upper_21  ierr_dig_21  vcm_route  vdd vss  hebbian_mult
XMPRED_r_21_22  i_pred_21  vw_route_21_22  vss  vss  sky130_fd_pr__nfet_01v8  w=4  l=0.35
Cw_route_21_22  vw_route_21_22  vss  200f
R_bleed_21_22  vw_route_21_22  vss  10000meg
XMN4_r_21_22  vw_route_21_22  we_route  iwrite_route_21_22  vss  sky130_fd_pr__nfet_01v8  w=0.5  l=0.5
X_rhebb_21_22  iwrite_route_21_22  inp_upper_22  ierr_dig_21  vcm_route  vdd vss  hebbian_mult
XMPRED_r_21_23  i_pred_21  vw_route_21_23  vss  vss  sky130_fd_pr__nfet_01v8  w=4  l=0.35
Cw_route_21_23  vw_route_21_23  vss  200f
R_bleed_21_23  vw_route_21_23  vss  10000meg
XMN4_r_21_23  vw_route_21_23  we_route  iwrite_route_21_23  vss  sky130_fd_pr__nfet_01v8  w=0.5  l=0.5
X_rhebb_21_23  iwrite_route_21_23  inp_upper_23  ierr_dig_21  vcm_route  vdd vss  hebbian_mult
XMPRED_r_21_24  i_pred_21  vw_route_21_24  vss  vss  sky130_fd_pr__nfet_01v8  w=4  l=0.35
Cw_route_21_24  vw_route_21_24  vss  200f
R_bleed_21_24  vw_route_21_24  vss  10000meg
XMN4_r_21_24  vw_route_21_24  we_route  iwrite_route_21_24  vss  sky130_fd_pr__nfet_01v8  w=0.5  l=0.5
X_rhebb_21_24  iwrite_route_21_24  inp_upper_24  ierr_dig_21  vcm_route  vdd vss  hebbian_mult
XMPRED_r_21_25  i_pred_21  vw_route_21_25  vss  vss  sky130_fd_pr__nfet_01v8  w=4  l=0.35
Cw_route_21_25  vw_route_21_25  vss  200f
R_bleed_21_25  vw_route_21_25  vss  10000meg
XMN4_r_21_25  vw_route_21_25  we_route  iwrite_route_21_25  vss  sky130_fd_pr__nfet_01v8  w=0.5  l=0.5
X_rhebb_21_25  iwrite_route_21_25  inp_upper_25  ierr_dig_21  vcm_route  vdd vss  hebbian_mult
XMPRED_r_21_26  i_pred_21  vw_route_21_26  vss  vss  sky130_fd_pr__nfet_01v8  w=4  l=0.35
Cw_route_21_26  vw_route_21_26  vss  200f
R_bleed_21_26  vw_route_21_26  vss  10000meg
XMN4_r_21_26  vw_route_21_26  we_route  iwrite_route_21_26  vss  sky130_fd_pr__nfet_01v8  w=0.5  l=0.5
X_rhebb_21_26  iwrite_route_21_26  inp_upper_26  ierr_dig_21  vcm_route  vdd vss  hebbian_mult
XMPRED_r_21_27  i_pred_21  vw_route_21_27  vss  vss  sky130_fd_pr__nfet_01v8  w=4  l=0.35
Cw_route_21_27  vw_route_21_27  vss  200f
R_bleed_21_27  vw_route_21_27  vss  10000meg
XMN4_r_21_27  vw_route_21_27  we_route  iwrite_route_21_27  vss  sky130_fd_pr__nfet_01v8  w=0.5  l=0.5
X_rhebb_21_27  iwrite_route_21_27  inp_upper_27  ierr_dig_21  vcm_route  vdd vss  hebbian_mult
XMPRED_r_21_28  i_pred_21  vw_route_21_28  vss  vss  sky130_fd_pr__nfet_01v8  w=4  l=0.35
Cw_route_21_28  vw_route_21_28  vss  200f
R_bleed_21_28  vw_route_21_28  vss  10000meg
XMN4_r_21_28  vw_route_21_28  we_route  iwrite_route_21_28  vss  sky130_fd_pr__nfet_01v8  w=0.5  l=0.5
X_rhebb_21_28  iwrite_route_21_28  inp_upper_28  ierr_dig_21  vcm_route  vdd vss  hebbian_mult
XMPRED_r_21_29  i_pred_21  vw_route_21_29  vss  vss  sky130_fd_pr__nfet_01v8  w=4  l=0.35
Cw_route_21_29  vw_route_21_29  vss  200f
R_bleed_21_29  vw_route_21_29  vss  10000meg
XMN4_r_21_29  vw_route_21_29  we_route  iwrite_route_21_29  vss  sky130_fd_pr__nfet_01v8  w=0.5  l=0.5
X_rhebb_21_29  iwrite_route_21_29  inp_upper_29  ierr_dig_21  vcm_route  vdd vss  hebbian_mult
XMPRED_r_21_30  i_pred_21  vw_route_21_30  vss  vss  sky130_fd_pr__nfet_01v8  w=4  l=0.35
Cw_route_21_30  vw_route_21_30  vss  200f
R_bleed_21_30  vw_route_21_30  vss  10000meg
XMN4_r_21_30  vw_route_21_30  we_route  iwrite_route_21_30  vss  sky130_fd_pr__nfet_01v8  w=0.5  l=0.5
X_rhebb_21_30  iwrite_route_21_30  inp_upper_30  ierr_dig_21  vcm_route  vdd vss  hebbian_mult
XMPRED_r_21_31  i_pred_21  vw_route_21_31  vss  vss  sky130_fd_pr__nfet_01v8  w=4  l=0.35
Cw_route_21_31  vw_route_21_31  vss  200f
R_bleed_21_31  vw_route_21_31  vss  10000meg
XMN4_r_21_31  vw_route_21_31  we_route  iwrite_route_21_31  vss  sky130_fd_pr__nfet_01v8  w=0.5  l=0.5
X_rhebb_21_31  iwrite_route_21_31  inp_upper_31  ierr_dig_21  vcm_route  vdd vss  hebbian_mult

* ── Destination row 22 ── 32 source connections ──────────────────────────
XMPRED_r_22_0  i_pred_22  vw_route_22_0  vss  vss  sky130_fd_pr__nfet_01v8  w=4  l=0.35
Cw_route_22_0  vw_route_22_0  vss  200f
R_bleed_22_0  vw_route_22_0  vss  10000meg
XMN4_r_22_0  vw_route_22_0  we_route  iwrite_route_22_0  vss  sky130_fd_pr__nfet_01v8  w=0.5  l=0.5
X_rhebb_22_0  iwrite_route_22_0  inp_upper_0  ierr_dig_22  vcm_route  vdd vss  hebbian_mult
XMPRED_r_22_1  i_pred_22  vw_route_22_1  vss  vss  sky130_fd_pr__nfet_01v8  w=4  l=0.35
Cw_route_22_1  vw_route_22_1  vss  200f
R_bleed_22_1  vw_route_22_1  vss  10000meg
XMN4_r_22_1  vw_route_22_1  we_route  iwrite_route_22_1  vss  sky130_fd_pr__nfet_01v8  w=0.5  l=0.5
X_rhebb_22_1  iwrite_route_22_1  inp_upper_1  ierr_dig_22  vcm_route  vdd vss  hebbian_mult
XMPRED_r_22_2  i_pred_22  vw_route_22_2  vss  vss  sky130_fd_pr__nfet_01v8  w=4  l=0.35
Cw_route_22_2  vw_route_22_2  vss  200f
R_bleed_22_2  vw_route_22_2  vss  10000meg
XMN4_r_22_2  vw_route_22_2  we_route  iwrite_route_22_2  vss  sky130_fd_pr__nfet_01v8  w=0.5  l=0.5
X_rhebb_22_2  iwrite_route_22_2  inp_upper_2  ierr_dig_22  vcm_route  vdd vss  hebbian_mult
XMPRED_r_22_3  i_pred_22  vw_route_22_3  vss  vss  sky130_fd_pr__nfet_01v8  w=4  l=0.35
Cw_route_22_3  vw_route_22_3  vss  200f
R_bleed_22_3  vw_route_22_3  vss  10000meg
XMN4_r_22_3  vw_route_22_3  we_route  iwrite_route_22_3  vss  sky130_fd_pr__nfet_01v8  w=0.5  l=0.5
X_rhebb_22_3  iwrite_route_22_3  inp_upper_3  ierr_dig_22  vcm_route  vdd vss  hebbian_mult
XMPRED_r_22_4  i_pred_22  vw_route_22_4  vss  vss  sky130_fd_pr__nfet_01v8  w=4  l=0.35
Cw_route_22_4  vw_route_22_4  vss  200f
R_bleed_22_4  vw_route_22_4  vss  10000meg
XMN4_r_22_4  vw_route_22_4  we_route  iwrite_route_22_4  vss  sky130_fd_pr__nfet_01v8  w=0.5  l=0.5
X_rhebb_22_4  iwrite_route_22_4  inp_upper_4  ierr_dig_22  vcm_route  vdd vss  hebbian_mult
XMPRED_r_22_5  i_pred_22  vw_route_22_5  vss  vss  sky130_fd_pr__nfet_01v8  w=4  l=0.35
Cw_route_22_5  vw_route_22_5  vss  200f
R_bleed_22_5  vw_route_22_5  vss  10000meg
XMN4_r_22_5  vw_route_22_5  we_route  iwrite_route_22_5  vss  sky130_fd_pr__nfet_01v8  w=0.5  l=0.5
X_rhebb_22_5  iwrite_route_22_5  inp_upper_5  ierr_dig_22  vcm_route  vdd vss  hebbian_mult
XMPRED_r_22_6  i_pred_22  vw_route_22_6  vss  vss  sky130_fd_pr__nfet_01v8  w=4  l=0.35
Cw_route_22_6  vw_route_22_6  vss  200f
R_bleed_22_6  vw_route_22_6  vss  10000meg
XMN4_r_22_6  vw_route_22_6  we_route  iwrite_route_22_6  vss  sky130_fd_pr__nfet_01v8  w=0.5  l=0.5
X_rhebb_22_6  iwrite_route_22_6  inp_upper_6  ierr_dig_22  vcm_route  vdd vss  hebbian_mult
XMPRED_r_22_7  i_pred_22  vw_route_22_7  vss  vss  sky130_fd_pr__nfet_01v8  w=4  l=0.35
Cw_route_22_7  vw_route_22_7  vss  200f
R_bleed_22_7  vw_route_22_7  vss  10000meg
XMN4_r_22_7  vw_route_22_7  we_route  iwrite_route_22_7  vss  sky130_fd_pr__nfet_01v8  w=0.5  l=0.5
X_rhebb_22_7  iwrite_route_22_7  inp_upper_7  ierr_dig_22  vcm_route  vdd vss  hebbian_mult
XMPRED_r_22_8  i_pred_22  vw_route_22_8  vss  vss  sky130_fd_pr__nfet_01v8  w=4  l=0.35
Cw_route_22_8  vw_route_22_8  vss  200f
R_bleed_22_8  vw_route_22_8  vss  10000meg
XMN4_r_22_8  vw_route_22_8  we_route  iwrite_route_22_8  vss  sky130_fd_pr__nfet_01v8  w=0.5  l=0.5
X_rhebb_22_8  iwrite_route_22_8  inp_upper_8  ierr_dig_22  vcm_route  vdd vss  hebbian_mult
XMPRED_r_22_9  i_pred_22  vw_route_22_9  vss  vss  sky130_fd_pr__nfet_01v8  w=4  l=0.35
Cw_route_22_9  vw_route_22_9  vss  200f
R_bleed_22_9  vw_route_22_9  vss  10000meg
XMN4_r_22_9  vw_route_22_9  we_route  iwrite_route_22_9  vss  sky130_fd_pr__nfet_01v8  w=0.5  l=0.5
X_rhebb_22_9  iwrite_route_22_9  inp_upper_9  ierr_dig_22  vcm_route  vdd vss  hebbian_mult
XMPRED_r_22_10  i_pred_22  vw_route_22_10  vss  vss  sky130_fd_pr__nfet_01v8  w=4  l=0.35
Cw_route_22_10  vw_route_22_10  vss  200f
R_bleed_22_10  vw_route_22_10  vss  10000meg
XMN4_r_22_10  vw_route_22_10  we_route  iwrite_route_22_10  vss  sky130_fd_pr__nfet_01v8  w=0.5  l=0.5
X_rhebb_22_10  iwrite_route_22_10  inp_upper_10  ierr_dig_22  vcm_route  vdd vss  hebbian_mult
XMPRED_r_22_11  i_pred_22  vw_route_22_11  vss  vss  sky130_fd_pr__nfet_01v8  w=4  l=0.35
Cw_route_22_11  vw_route_22_11  vss  200f
R_bleed_22_11  vw_route_22_11  vss  10000meg
XMN4_r_22_11  vw_route_22_11  we_route  iwrite_route_22_11  vss  sky130_fd_pr__nfet_01v8  w=0.5  l=0.5
X_rhebb_22_11  iwrite_route_22_11  inp_upper_11  ierr_dig_22  vcm_route  vdd vss  hebbian_mult
XMPRED_r_22_12  i_pred_22  vw_route_22_12  vss  vss  sky130_fd_pr__nfet_01v8  w=4  l=0.35
Cw_route_22_12  vw_route_22_12  vss  200f
R_bleed_22_12  vw_route_22_12  vss  10000meg
XMN4_r_22_12  vw_route_22_12  we_route  iwrite_route_22_12  vss  sky130_fd_pr__nfet_01v8  w=0.5  l=0.5
X_rhebb_22_12  iwrite_route_22_12  inp_upper_12  ierr_dig_22  vcm_route  vdd vss  hebbian_mult
XMPRED_r_22_13  i_pred_22  vw_route_22_13  vss  vss  sky130_fd_pr__nfet_01v8  w=4  l=0.35
Cw_route_22_13  vw_route_22_13  vss  200f
R_bleed_22_13  vw_route_22_13  vss  10000meg
XMN4_r_22_13  vw_route_22_13  we_route  iwrite_route_22_13  vss  sky130_fd_pr__nfet_01v8  w=0.5  l=0.5
X_rhebb_22_13  iwrite_route_22_13  inp_upper_13  ierr_dig_22  vcm_route  vdd vss  hebbian_mult
XMPRED_r_22_14  i_pred_22  vw_route_22_14  vss  vss  sky130_fd_pr__nfet_01v8  w=4  l=0.35
Cw_route_22_14  vw_route_22_14  vss  200f
R_bleed_22_14  vw_route_22_14  vss  10000meg
XMN4_r_22_14  vw_route_22_14  we_route  iwrite_route_22_14  vss  sky130_fd_pr__nfet_01v8  w=0.5  l=0.5
X_rhebb_22_14  iwrite_route_22_14  inp_upper_14  ierr_dig_22  vcm_route  vdd vss  hebbian_mult
XMPRED_r_22_15  i_pred_22  vw_route_22_15  vss  vss  sky130_fd_pr__nfet_01v8  w=4  l=0.35
Cw_route_22_15  vw_route_22_15  vss  200f
R_bleed_22_15  vw_route_22_15  vss  10000meg
XMN4_r_22_15  vw_route_22_15  we_route  iwrite_route_22_15  vss  sky130_fd_pr__nfet_01v8  w=0.5  l=0.5
X_rhebb_22_15  iwrite_route_22_15  inp_upper_15  ierr_dig_22  vcm_route  vdd vss  hebbian_mult
XMPRED_r_22_16  i_pred_22  vw_route_22_16  vss  vss  sky130_fd_pr__nfet_01v8  w=4  l=0.35
Cw_route_22_16  vw_route_22_16  vss  200f
R_bleed_22_16  vw_route_22_16  vss  10000meg
XMN4_r_22_16  vw_route_22_16  we_route  iwrite_route_22_16  vss  sky130_fd_pr__nfet_01v8  w=0.5  l=0.5
X_rhebb_22_16  iwrite_route_22_16  inp_upper_16  ierr_dig_22  vcm_route  vdd vss  hebbian_mult
XMPRED_r_22_17  i_pred_22  vw_route_22_17  vss  vss  sky130_fd_pr__nfet_01v8  w=4  l=0.35
Cw_route_22_17  vw_route_22_17  vss  200f
R_bleed_22_17  vw_route_22_17  vss  10000meg
XMN4_r_22_17  vw_route_22_17  we_route  iwrite_route_22_17  vss  sky130_fd_pr__nfet_01v8  w=0.5  l=0.5
X_rhebb_22_17  iwrite_route_22_17  inp_upper_17  ierr_dig_22  vcm_route  vdd vss  hebbian_mult
XMPRED_r_22_18  i_pred_22  vw_route_22_18  vss  vss  sky130_fd_pr__nfet_01v8  w=4  l=0.35
Cw_route_22_18  vw_route_22_18  vss  200f
R_bleed_22_18  vw_route_22_18  vss  10000meg
XMN4_r_22_18  vw_route_22_18  we_route  iwrite_route_22_18  vss  sky130_fd_pr__nfet_01v8  w=0.5  l=0.5
X_rhebb_22_18  iwrite_route_22_18  inp_upper_18  ierr_dig_22  vcm_route  vdd vss  hebbian_mult
XMPRED_r_22_19  i_pred_22  vw_route_22_19  vss  vss  sky130_fd_pr__nfet_01v8  w=4  l=0.35
Cw_route_22_19  vw_route_22_19  vss  200f
R_bleed_22_19  vw_route_22_19  vss  10000meg
XMN4_r_22_19  vw_route_22_19  we_route  iwrite_route_22_19  vss  sky130_fd_pr__nfet_01v8  w=0.5  l=0.5
X_rhebb_22_19  iwrite_route_22_19  inp_upper_19  ierr_dig_22  vcm_route  vdd vss  hebbian_mult
XMPRED_r_22_20  i_pred_22  vw_route_22_20  vss  vss  sky130_fd_pr__nfet_01v8  w=4  l=0.35
Cw_route_22_20  vw_route_22_20  vss  200f
R_bleed_22_20  vw_route_22_20  vss  10000meg
XMN4_r_22_20  vw_route_22_20  we_route  iwrite_route_22_20  vss  sky130_fd_pr__nfet_01v8  w=0.5  l=0.5
X_rhebb_22_20  iwrite_route_22_20  inp_upper_20  ierr_dig_22  vcm_route  vdd vss  hebbian_mult
XMPRED_r_22_21  i_pred_22  vw_route_22_21  vss  vss  sky130_fd_pr__nfet_01v8  w=4  l=0.35
Cw_route_22_21  vw_route_22_21  vss  200f
R_bleed_22_21  vw_route_22_21  vss  10000meg
XMN4_r_22_21  vw_route_22_21  we_route  iwrite_route_22_21  vss  sky130_fd_pr__nfet_01v8  w=0.5  l=0.5
X_rhebb_22_21  iwrite_route_22_21  inp_upper_21  ierr_dig_22  vcm_route  vdd vss  hebbian_mult
XMPRED_r_22_22  i_pred_22  vw_route_22_22  vss  vss  sky130_fd_pr__nfet_01v8  w=4  l=0.35
Cw_route_22_22  vw_route_22_22  vss  200f
R_bleed_22_22  vw_route_22_22  vss  10000meg
XMN4_r_22_22  vw_route_22_22  we_route  iwrite_route_22_22  vss  sky130_fd_pr__nfet_01v8  w=0.5  l=0.5
X_rhebb_22_22  iwrite_route_22_22  inp_upper_22  ierr_dig_22  vcm_route  vdd vss  hebbian_mult
XMPRED_r_22_23  i_pred_22  vw_route_22_23  vss  vss  sky130_fd_pr__nfet_01v8  w=4  l=0.35
Cw_route_22_23  vw_route_22_23  vss  200f
R_bleed_22_23  vw_route_22_23  vss  10000meg
XMN4_r_22_23  vw_route_22_23  we_route  iwrite_route_22_23  vss  sky130_fd_pr__nfet_01v8  w=0.5  l=0.5
X_rhebb_22_23  iwrite_route_22_23  inp_upper_23  ierr_dig_22  vcm_route  vdd vss  hebbian_mult
XMPRED_r_22_24  i_pred_22  vw_route_22_24  vss  vss  sky130_fd_pr__nfet_01v8  w=4  l=0.35
Cw_route_22_24  vw_route_22_24  vss  200f
R_bleed_22_24  vw_route_22_24  vss  10000meg
XMN4_r_22_24  vw_route_22_24  we_route  iwrite_route_22_24  vss  sky130_fd_pr__nfet_01v8  w=0.5  l=0.5
X_rhebb_22_24  iwrite_route_22_24  inp_upper_24  ierr_dig_22  vcm_route  vdd vss  hebbian_mult
XMPRED_r_22_25  i_pred_22  vw_route_22_25  vss  vss  sky130_fd_pr__nfet_01v8  w=4  l=0.35
Cw_route_22_25  vw_route_22_25  vss  200f
R_bleed_22_25  vw_route_22_25  vss  10000meg
XMN4_r_22_25  vw_route_22_25  we_route  iwrite_route_22_25  vss  sky130_fd_pr__nfet_01v8  w=0.5  l=0.5
X_rhebb_22_25  iwrite_route_22_25  inp_upper_25  ierr_dig_22  vcm_route  vdd vss  hebbian_mult
XMPRED_r_22_26  i_pred_22  vw_route_22_26  vss  vss  sky130_fd_pr__nfet_01v8  w=4  l=0.35
Cw_route_22_26  vw_route_22_26  vss  200f
R_bleed_22_26  vw_route_22_26  vss  10000meg
XMN4_r_22_26  vw_route_22_26  we_route  iwrite_route_22_26  vss  sky130_fd_pr__nfet_01v8  w=0.5  l=0.5
X_rhebb_22_26  iwrite_route_22_26  inp_upper_26  ierr_dig_22  vcm_route  vdd vss  hebbian_mult
XMPRED_r_22_27  i_pred_22  vw_route_22_27  vss  vss  sky130_fd_pr__nfet_01v8  w=4  l=0.35
Cw_route_22_27  vw_route_22_27  vss  200f
R_bleed_22_27  vw_route_22_27  vss  10000meg
XMN4_r_22_27  vw_route_22_27  we_route  iwrite_route_22_27  vss  sky130_fd_pr__nfet_01v8  w=0.5  l=0.5
X_rhebb_22_27  iwrite_route_22_27  inp_upper_27  ierr_dig_22  vcm_route  vdd vss  hebbian_mult
XMPRED_r_22_28  i_pred_22  vw_route_22_28  vss  vss  sky130_fd_pr__nfet_01v8  w=4  l=0.35
Cw_route_22_28  vw_route_22_28  vss  200f
R_bleed_22_28  vw_route_22_28  vss  10000meg
XMN4_r_22_28  vw_route_22_28  we_route  iwrite_route_22_28  vss  sky130_fd_pr__nfet_01v8  w=0.5  l=0.5
X_rhebb_22_28  iwrite_route_22_28  inp_upper_28  ierr_dig_22  vcm_route  vdd vss  hebbian_mult
XMPRED_r_22_29  i_pred_22  vw_route_22_29  vss  vss  sky130_fd_pr__nfet_01v8  w=4  l=0.35
Cw_route_22_29  vw_route_22_29  vss  200f
R_bleed_22_29  vw_route_22_29  vss  10000meg
XMN4_r_22_29  vw_route_22_29  we_route  iwrite_route_22_29  vss  sky130_fd_pr__nfet_01v8  w=0.5  l=0.5
X_rhebb_22_29  iwrite_route_22_29  inp_upper_29  ierr_dig_22  vcm_route  vdd vss  hebbian_mult
XMPRED_r_22_30  i_pred_22  vw_route_22_30  vss  vss  sky130_fd_pr__nfet_01v8  w=4  l=0.35
Cw_route_22_30  vw_route_22_30  vss  200f
R_bleed_22_30  vw_route_22_30  vss  10000meg
XMN4_r_22_30  vw_route_22_30  we_route  iwrite_route_22_30  vss  sky130_fd_pr__nfet_01v8  w=0.5  l=0.5
X_rhebb_22_30  iwrite_route_22_30  inp_upper_30  ierr_dig_22  vcm_route  vdd vss  hebbian_mult
XMPRED_r_22_31  i_pred_22  vw_route_22_31  vss  vss  sky130_fd_pr__nfet_01v8  w=4  l=0.35
Cw_route_22_31  vw_route_22_31  vss  200f
R_bleed_22_31  vw_route_22_31  vss  10000meg
XMN4_r_22_31  vw_route_22_31  we_route  iwrite_route_22_31  vss  sky130_fd_pr__nfet_01v8  w=0.5  l=0.5
X_rhebb_22_31  iwrite_route_22_31  inp_upper_31  ierr_dig_22  vcm_route  vdd vss  hebbian_mult

* ── Destination row 23 ── 32 source connections ──────────────────────────
XMPRED_r_23_0  i_pred_23  vw_route_23_0  vss  vss  sky130_fd_pr__nfet_01v8  w=4  l=0.35
Cw_route_23_0  vw_route_23_0  vss  200f
R_bleed_23_0  vw_route_23_0  vss  10000meg
XMN4_r_23_0  vw_route_23_0  we_route  iwrite_route_23_0  vss  sky130_fd_pr__nfet_01v8  w=0.5  l=0.5
X_rhebb_23_0  iwrite_route_23_0  inp_upper_0  ierr_dig_23  vcm_route  vdd vss  hebbian_mult
XMPRED_r_23_1  i_pred_23  vw_route_23_1  vss  vss  sky130_fd_pr__nfet_01v8  w=4  l=0.35
Cw_route_23_1  vw_route_23_1  vss  200f
R_bleed_23_1  vw_route_23_1  vss  10000meg
XMN4_r_23_1  vw_route_23_1  we_route  iwrite_route_23_1  vss  sky130_fd_pr__nfet_01v8  w=0.5  l=0.5
X_rhebb_23_1  iwrite_route_23_1  inp_upper_1  ierr_dig_23  vcm_route  vdd vss  hebbian_mult
XMPRED_r_23_2  i_pred_23  vw_route_23_2  vss  vss  sky130_fd_pr__nfet_01v8  w=4  l=0.35
Cw_route_23_2  vw_route_23_2  vss  200f
R_bleed_23_2  vw_route_23_2  vss  10000meg
XMN4_r_23_2  vw_route_23_2  we_route  iwrite_route_23_2  vss  sky130_fd_pr__nfet_01v8  w=0.5  l=0.5
X_rhebb_23_2  iwrite_route_23_2  inp_upper_2  ierr_dig_23  vcm_route  vdd vss  hebbian_mult
XMPRED_r_23_3  i_pred_23  vw_route_23_3  vss  vss  sky130_fd_pr__nfet_01v8  w=4  l=0.35
Cw_route_23_3  vw_route_23_3  vss  200f
R_bleed_23_3  vw_route_23_3  vss  10000meg
XMN4_r_23_3  vw_route_23_3  we_route  iwrite_route_23_3  vss  sky130_fd_pr__nfet_01v8  w=0.5  l=0.5
X_rhebb_23_3  iwrite_route_23_3  inp_upper_3  ierr_dig_23  vcm_route  vdd vss  hebbian_mult
XMPRED_r_23_4  i_pred_23  vw_route_23_4  vss  vss  sky130_fd_pr__nfet_01v8  w=4  l=0.35
Cw_route_23_4  vw_route_23_4  vss  200f
R_bleed_23_4  vw_route_23_4  vss  10000meg
XMN4_r_23_4  vw_route_23_4  we_route  iwrite_route_23_4  vss  sky130_fd_pr__nfet_01v8  w=0.5  l=0.5
X_rhebb_23_4  iwrite_route_23_4  inp_upper_4  ierr_dig_23  vcm_route  vdd vss  hebbian_mult
XMPRED_r_23_5  i_pred_23  vw_route_23_5  vss  vss  sky130_fd_pr__nfet_01v8  w=4  l=0.35
Cw_route_23_5  vw_route_23_5  vss  200f
R_bleed_23_5  vw_route_23_5  vss  10000meg
XMN4_r_23_5  vw_route_23_5  we_route  iwrite_route_23_5  vss  sky130_fd_pr__nfet_01v8  w=0.5  l=0.5
X_rhebb_23_5  iwrite_route_23_5  inp_upper_5  ierr_dig_23  vcm_route  vdd vss  hebbian_mult
XMPRED_r_23_6  i_pred_23  vw_route_23_6  vss  vss  sky130_fd_pr__nfet_01v8  w=4  l=0.35
Cw_route_23_6  vw_route_23_6  vss  200f
R_bleed_23_6  vw_route_23_6  vss  10000meg
XMN4_r_23_6  vw_route_23_6  we_route  iwrite_route_23_6  vss  sky130_fd_pr__nfet_01v8  w=0.5  l=0.5
X_rhebb_23_6  iwrite_route_23_6  inp_upper_6  ierr_dig_23  vcm_route  vdd vss  hebbian_mult
XMPRED_r_23_7  i_pred_23  vw_route_23_7  vss  vss  sky130_fd_pr__nfet_01v8  w=4  l=0.35
Cw_route_23_7  vw_route_23_7  vss  200f
R_bleed_23_7  vw_route_23_7  vss  10000meg
XMN4_r_23_7  vw_route_23_7  we_route  iwrite_route_23_7  vss  sky130_fd_pr__nfet_01v8  w=0.5  l=0.5
X_rhebb_23_7  iwrite_route_23_7  inp_upper_7  ierr_dig_23  vcm_route  vdd vss  hebbian_mult
XMPRED_r_23_8  i_pred_23  vw_route_23_8  vss  vss  sky130_fd_pr__nfet_01v8  w=4  l=0.35
Cw_route_23_8  vw_route_23_8  vss  200f
R_bleed_23_8  vw_route_23_8  vss  10000meg
XMN4_r_23_8  vw_route_23_8  we_route  iwrite_route_23_8  vss  sky130_fd_pr__nfet_01v8  w=0.5  l=0.5
X_rhebb_23_8  iwrite_route_23_8  inp_upper_8  ierr_dig_23  vcm_route  vdd vss  hebbian_mult
XMPRED_r_23_9  i_pred_23  vw_route_23_9  vss  vss  sky130_fd_pr__nfet_01v8  w=4  l=0.35
Cw_route_23_9  vw_route_23_9  vss  200f
R_bleed_23_9  vw_route_23_9  vss  10000meg
XMN4_r_23_9  vw_route_23_9  we_route  iwrite_route_23_9  vss  sky130_fd_pr__nfet_01v8  w=0.5  l=0.5
X_rhebb_23_9  iwrite_route_23_9  inp_upper_9  ierr_dig_23  vcm_route  vdd vss  hebbian_mult
XMPRED_r_23_10  i_pred_23  vw_route_23_10  vss  vss  sky130_fd_pr__nfet_01v8  w=4  l=0.35
Cw_route_23_10  vw_route_23_10  vss  200f
R_bleed_23_10  vw_route_23_10  vss  10000meg
XMN4_r_23_10  vw_route_23_10  we_route  iwrite_route_23_10  vss  sky130_fd_pr__nfet_01v8  w=0.5  l=0.5
X_rhebb_23_10  iwrite_route_23_10  inp_upper_10  ierr_dig_23  vcm_route  vdd vss  hebbian_mult
XMPRED_r_23_11  i_pred_23  vw_route_23_11  vss  vss  sky130_fd_pr__nfet_01v8  w=4  l=0.35
Cw_route_23_11  vw_route_23_11  vss  200f
R_bleed_23_11  vw_route_23_11  vss  10000meg
XMN4_r_23_11  vw_route_23_11  we_route  iwrite_route_23_11  vss  sky130_fd_pr__nfet_01v8  w=0.5  l=0.5
X_rhebb_23_11  iwrite_route_23_11  inp_upper_11  ierr_dig_23  vcm_route  vdd vss  hebbian_mult
XMPRED_r_23_12  i_pred_23  vw_route_23_12  vss  vss  sky130_fd_pr__nfet_01v8  w=4  l=0.35
Cw_route_23_12  vw_route_23_12  vss  200f
R_bleed_23_12  vw_route_23_12  vss  10000meg
XMN4_r_23_12  vw_route_23_12  we_route  iwrite_route_23_12  vss  sky130_fd_pr__nfet_01v8  w=0.5  l=0.5
X_rhebb_23_12  iwrite_route_23_12  inp_upper_12  ierr_dig_23  vcm_route  vdd vss  hebbian_mult
XMPRED_r_23_13  i_pred_23  vw_route_23_13  vss  vss  sky130_fd_pr__nfet_01v8  w=4  l=0.35
Cw_route_23_13  vw_route_23_13  vss  200f
R_bleed_23_13  vw_route_23_13  vss  10000meg
XMN4_r_23_13  vw_route_23_13  we_route  iwrite_route_23_13  vss  sky130_fd_pr__nfet_01v8  w=0.5  l=0.5
X_rhebb_23_13  iwrite_route_23_13  inp_upper_13  ierr_dig_23  vcm_route  vdd vss  hebbian_mult
XMPRED_r_23_14  i_pred_23  vw_route_23_14  vss  vss  sky130_fd_pr__nfet_01v8  w=4  l=0.35
Cw_route_23_14  vw_route_23_14  vss  200f
R_bleed_23_14  vw_route_23_14  vss  10000meg
XMN4_r_23_14  vw_route_23_14  we_route  iwrite_route_23_14  vss  sky130_fd_pr__nfet_01v8  w=0.5  l=0.5
X_rhebb_23_14  iwrite_route_23_14  inp_upper_14  ierr_dig_23  vcm_route  vdd vss  hebbian_mult
XMPRED_r_23_15  i_pred_23  vw_route_23_15  vss  vss  sky130_fd_pr__nfet_01v8  w=4  l=0.35
Cw_route_23_15  vw_route_23_15  vss  200f
R_bleed_23_15  vw_route_23_15  vss  10000meg
XMN4_r_23_15  vw_route_23_15  we_route  iwrite_route_23_15  vss  sky130_fd_pr__nfet_01v8  w=0.5  l=0.5
X_rhebb_23_15  iwrite_route_23_15  inp_upper_15  ierr_dig_23  vcm_route  vdd vss  hebbian_mult
XMPRED_r_23_16  i_pred_23  vw_route_23_16  vss  vss  sky130_fd_pr__nfet_01v8  w=4  l=0.35
Cw_route_23_16  vw_route_23_16  vss  200f
R_bleed_23_16  vw_route_23_16  vss  10000meg
XMN4_r_23_16  vw_route_23_16  we_route  iwrite_route_23_16  vss  sky130_fd_pr__nfet_01v8  w=0.5  l=0.5
X_rhebb_23_16  iwrite_route_23_16  inp_upper_16  ierr_dig_23  vcm_route  vdd vss  hebbian_mult
XMPRED_r_23_17  i_pred_23  vw_route_23_17  vss  vss  sky130_fd_pr__nfet_01v8  w=4  l=0.35
Cw_route_23_17  vw_route_23_17  vss  200f
R_bleed_23_17  vw_route_23_17  vss  10000meg
XMN4_r_23_17  vw_route_23_17  we_route  iwrite_route_23_17  vss  sky130_fd_pr__nfet_01v8  w=0.5  l=0.5
X_rhebb_23_17  iwrite_route_23_17  inp_upper_17  ierr_dig_23  vcm_route  vdd vss  hebbian_mult
XMPRED_r_23_18  i_pred_23  vw_route_23_18  vss  vss  sky130_fd_pr__nfet_01v8  w=4  l=0.35
Cw_route_23_18  vw_route_23_18  vss  200f
R_bleed_23_18  vw_route_23_18  vss  10000meg
XMN4_r_23_18  vw_route_23_18  we_route  iwrite_route_23_18  vss  sky130_fd_pr__nfet_01v8  w=0.5  l=0.5
X_rhebb_23_18  iwrite_route_23_18  inp_upper_18  ierr_dig_23  vcm_route  vdd vss  hebbian_mult
XMPRED_r_23_19  i_pred_23  vw_route_23_19  vss  vss  sky130_fd_pr__nfet_01v8  w=4  l=0.35
Cw_route_23_19  vw_route_23_19  vss  200f
R_bleed_23_19  vw_route_23_19  vss  10000meg
XMN4_r_23_19  vw_route_23_19  we_route  iwrite_route_23_19  vss  sky130_fd_pr__nfet_01v8  w=0.5  l=0.5
X_rhebb_23_19  iwrite_route_23_19  inp_upper_19  ierr_dig_23  vcm_route  vdd vss  hebbian_mult
XMPRED_r_23_20  i_pred_23  vw_route_23_20  vss  vss  sky130_fd_pr__nfet_01v8  w=4  l=0.35
Cw_route_23_20  vw_route_23_20  vss  200f
R_bleed_23_20  vw_route_23_20  vss  10000meg
XMN4_r_23_20  vw_route_23_20  we_route  iwrite_route_23_20  vss  sky130_fd_pr__nfet_01v8  w=0.5  l=0.5
X_rhebb_23_20  iwrite_route_23_20  inp_upper_20  ierr_dig_23  vcm_route  vdd vss  hebbian_mult
XMPRED_r_23_21  i_pred_23  vw_route_23_21  vss  vss  sky130_fd_pr__nfet_01v8  w=4  l=0.35
Cw_route_23_21  vw_route_23_21  vss  200f
R_bleed_23_21  vw_route_23_21  vss  10000meg
XMN4_r_23_21  vw_route_23_21  we_route  iwrite_route_23_21  vss  sky130_fd_pr__nfet_01v8  w=0.5  l=0.5
X_rhebb_23_21  iwrite_route_23_21  inp_upper_21  ierr_dig_23  vcm_route  vdd vss  hebbian_mult
XMPRED_r_23_22  i_pred_23  vw_route_23_22  vss  vss  sky130_fd_pr__nfet_01v8  w=4  l=0.35
Cw_route_23_22  vw_route_23_22  vss  200f
R_bleed_23_22  vw_route_23_22  vss  10000meg
XMN4_r_23_22  vw_route_23_22  we_route  iwrite_route_23_22  vss  sky130_fd_pr__nfet_01v8  w=0.5  l=0.5
X_rhebb_23_22  iwrite_route_23_22  inp_upper_22  ierr_dig_23  vcm_route  vdd vss  hebbian_mult
XMPRED_r_23_23  i_pred_23  vw_route_23_23  vss  vss  sky130_fd_pr__nfet_01v8  w=4  l=0.35
Cw_route_23_23  vw_route_23_23  vss  200f
R_bleed_23_23  vw_route_23_23  vss  10000meg
XMN4_r_23_23  vw_route_23_23  we_route  iwrite_route_23_23  vss  sky130_fd_pr__nfet_01v8  w=0.5  l=0.5
X_rhebb_23_23  iwrite_route_23_23  inp_upper_23  ierr_dig_23  vcm_route  vdd vss  hebbian_mult
XMPRED_r_23_24  i_pred_23  vw_route_23_24  vss  vss  sky130_fd_pr__nfet_01v8  w=4  l=0.35
Cw_route_23_24  vw_route_23_24  vss  200f
R_bleed_23_24  vw_route_23_24  vss  10000meg
XMN4_r_23_24  vw_route_23_24  we_route  iwrite_route_23_24  vss  sky130_fd_pr__nfet_01v8  w=0.5  l=0.5
X_rhebb_23_24  iwrite_route_23_24  inp_upper_24  ierr_dig_23  vcm_route  vdd vss  hebbian_mult
XMPRED_r_23_25  i_pred_23  vw_route_23_25  vss  vss  sky130_fd_pr__nfet_01v8  w=4  l=0.35
Cw_route_23_25  vw_route_23_25  vss  200f
R_bleed_23_25  vw_route_23_25  vss  10000meg
XMN4_r_23_25  vw_route_23_25  we_route  iwrite_route_23_25  vss  sky130_fd_pr__nfet_01v8  w=0.5  l=0.5
X_rhebb_23_25  iwrite_route_23_25  inp_upper_25  ierr_dig_23  vcm_route  vdd vss  hebbian_mult
XMPRED_r_23_26  i_pred_23  vw_route_23_26  vss  vss  sky130_fd_pr__nfet_01v8  w=4  l=0.35
Cw_route_23_26  vw_route_23_26  vss  200f
R_bleed_23_26  vw_route_23_26  vss  10000meg
XMN4_r_23_26  vw_route_23_26  we_route  iwrite_route_23_26  vss  sky130_fd_pr__nfet_01v8  w=0.5  l=0.5
X_rhebb_23_26  iwrite_route_23_26  inp_upper_26  ierr_dig_23  vcm_route  vdd vss  hebbian_mult
XMPRED_r_23_27  i_pred_23  vw_route_23_27  vss  vss  sky130_fd_pr__nfet_01v8  w=4  l=0.35
Cw_route_23_27  vw_route_23_27  vss  200f
R_bleed_23_27  vw_route_23_27  vss  10000meg
XMN4_r_23_27  vw_route_23_27  we_route  iwrite_route_23_27  vss  sky130_fd_pr__nfet_01v8  w=0.5  l=0.5
X_rhebb_23_27  iwrite_route_23_27  inp_upper_27  ierr_dig_23  vcm_route  vdd vss  hebbian_mult
XMPRED_r_23_28  i_pred_23  vw_route_23_28  vss  vss  sky130_fd_pr__nfet_01v8  w=4  l=0.35
Cw_route_23_28  vw_route_23_28  vss  200f
R_bleed_23_28  vw_route_23_28  vss  10000meg
XMN4_r_23_28  vw_route_23_28  we_route  iwrite_route_23_28  vss  sky130_fd_pr__nfet_01v8  w=0.5  l=0.5
X_rhebb_23_28  iwrite_route_23_28  inp_upper_28  ierr_dig_23  vcm_route  vdd vss  hebbian_mult
XMPRED_r_23_29  i_pred_23  vw_route_23_29  vss  vss  sky130_fd_pr__nfet_01v8  w=4  l=0.35
Cw_route_23_29  vw_route_23_29  vss  200f
R_bleed_23_29  vw_route_23_29  vss  10000meg
XMN4_r_23_29  vw_route_23_29  we_route  iwrite_route_23_29  vss  sky130_fd_pr__nfet_01v8  w=0.5  l=0.5
X_rhebb_23_29  iwrite_route_23_29  inp_upper_29  ierr_dig_23  vcm_route  vdd vss  hebbian_mult
XMPRED_r_23_30  i_pred_23  vw_route_23_30  vss  vss  sky130_fd_pr__nfet_01v8  w=4  l=0.35
Cw_route_23_30  vw_route_23_30  vss  200f
R_bleed_23_30  vw_route_23_30  vss  10000meg
XMN4_r_23_30  vw_route_23_30  we_route  iwrite_route_23_30  vss  sky130_fd_pr__nfet_01v8  w=0.5  l=0.5
X_rhebb_23_30  iwrite_route_23_30  inp_upper_30  ierr_dig_23  vcm_route  vdd vss  hebbian_mult
XMPRED_r_23_31  i_pred_23  vw_route_23_31  vss  vss  sky130_fd_pr__nfet_01v8  w=4  l=0.35
Cw_route_23_31  vw_route_23_31  vss  200f
R_bleed_23_31  vw_route_23_31  vss  10000meg
XMN4_r_23_31  vw_route_23_31  we_route  iwrite_route_23_31  vss  sky130_fd_pr__nfet_01v8  w=0.5  l=0.5
X_rhebb_23_31  iwrite_route_23_31  inp_upper_31  ierr_dig_23  vcm_route  vdd vss  hebbian_mult

* ── Destination row 24 ── 32 source connections ──────────────────────────
XMPRED_r_24_0  i_pred_24  vw_route_24_0  vss  vss  sky130_fd_pr__nfet_01v8  w=4  l=0.35
Cw_route_24_0  vw_route_24_0  vss  200f
R_bleed_24_0  vw_route_24_0  vss  10000meg
XMN4_r_24_0  vw_route_24_0  we_route  iwrite_route_24_0  vss  sky130_fd_pr__nfet_01v8  w=0.5  l=0.5
X_rhebb_24_0  iwrite_route_24_0  inp_upper_0  ierr_dig_24  vcm_route  vdd vss  hebbian_mult
XMPRED_r_24_1  i_pred_24  vw_route_24_1  vss  vss  sky130_fd_pr__nfet_01v8  w=4  l=0.35
Cw_route_24_1  vw_route_24_1  vss  200f
R_bleed_24_1  vw_route_24_1  vss  10000meg
XMN4_r_24_1  vw_route_24_1  we_route  iwrite_route_24_1  vss  sky130_fd_pr__nfet_01v8  w=0.5  l=0.5
X_rhebb_24_1  iwrite_route_24_1  inp_upper_1  ierr_dig_24  vcm_route  vdd vss  hebbian_mult
XMPRED_r_24_2  i_pred_24  vw_route_24_2  vss  vss  sky130_fd_pr__nfet_01v8  w=4  l=0.35
Cw_route_24_2  vw_route_24_2  vss  200f
R_bleed_24_2  vw_route_24_2  vss  10000meg
XMN4_r_24_2  vw_route_24_2  we_route  iwrite_route_24_2  vss  sky130_fd_pr__nfet_01v8  w=0.5  l=0.5
X_rhebb_24_2  iwrite_route_24_2  inp_upper_2  ierr_dig_24  vcm_route  vdd vss  hebbian_mult
XMPRED_r_24_3  i_pred_24  vw_route_24_3  vss  vss  sky130_fd_pr__nfet_01v8  w=4  l=0.35
Cw_route_24_3  vw_route_24_3  vss  200f
R_bleed_24_3  vw_route_24_3  vss  10000meg
XMN4_r_24_3  vw_route_24_3  we_route  iwrite_route_24_3  vss  sky130_fd_pr__nfet_01v8  w=0.5  l=0.5
X_rhebb_24_3  iwrite_route_24_3  inp_upper_3  ierr_dig_24  vcm_route  vdd vss  hebbian_mult
XMPRED_r_24_4  i_pred_24  vw_route_24_4  vss  vss  sky130_fd_pr__nfet_01v8  w=4  l=0.35
Cw_route_24_4  vw_route_24_4  vss  200f
R_bleed_24_4  vw_route_24_4  vss  10000meg
XMN4_r_24_4  vw_route_24_4  we_route  iwrite_route_24_4  vss  sky130_fd_pr__nfet_01v8  w=0.5  l=0.5
X_rhebb_24_4  iwrite_route_24_4  inp_upper_4  ierr_dig_24  vcm_route  vdd vss  hebbian_mult
XMPRED_r_24_5  i_pred_24  vw_route_24_5  vss  vss  sky130_fd_pr__nfet_01v8  w=4  l=0.35
Cw_route_24_5  vw_route_24_5  vss  200f
R_bleed_24_5  vw_route_24_5  vss  10000meg
XMN4_r_24_5  vw_route_24_5  we_route  iwrite_route_24_5  vss  sky130_fd_pr__nfet_01v8  w=0.5  l=0.5
X_rhebb_24_5  iwrite_route_24_5  inp_upper_5  ierr_dig_24  vcm_route  vdd vss  hebbian_mult
XMPRED_r_24_6  i_pred_24  vw_route_24_6  vss  vss  sky130_fd_pr__nfet_01v8  w=4  l=0.35
Cw_route_24_6  vw_route_24_6  vss  200f
R_bleed_24_6  vw_route_24_6  vss  10000meg
XMN4_r_24_6  vw_route_24_6  we_route  iwrite_route_24_6  vss  sky130_fd_pr__nfet_01v8  w=0.5  l=0.5
X_rhebb_24_6  iwrite_route_24_6  inp_upper_6  ierr_dig_24  vcm_route  vdd vss  hebbian_mult
XMPRED_r_24_7  i_pred_24  vw_route_24_7  vss  vss  sky130_fd_pr__nfet_01v8  w=4  l=0.35
Cw_route_24_7  vw_route_24_7  vss  200f
R_bleed_24_7  vw_route_24_7  vss  10000meg
XMN4_r_24_7  vw_route_24_7  we_route  iwrite_route_24_7  vss  sky130_fd_pr__nfet_01v8  w=0.5  l=0.5
X_rhebb_24_7  iwrite_route_24_7  inp_upper_7  ierr_dig_24  vcm_route  vdd vss  hebbian_mult
XMPRED_r_24_8  i_pred_24  vw_route_24_8  vss  vss  sky130_fd_pr__nfet_01v8  w=4  l=0.35
Cw_route_24_8  vw_route_24_8  vss  200f
R_bleed_24_8  vw_route_24_8  vss  10000meg
XMN4_r_24_8  vw_route_24_8  we_route  iwrite_route_24_8  vss  sky130_fd_pr__nfet_01v8  w=0.5  l=0.5
X_rhebb_24_8  iwrite_route_24_8  inp_upper_8  ierr_dig_24  vcm_route  vdd vss  hebbian_mult
XMPRED_r_24_9  i_pred_24  vw_route_24_9  vss  vss  sky130_fd_pr__nfet_01v8  w=4  l=0.35
Cw_route_24_9  vw_route_24_9  vss  200f
R_bleed_24_9  vw_route_24_9  vss  10000meg
XMN4_r_24_9  vw_route_24_9  we_route  iwrite_route_24_9  vss  sky130_fd_pr__nfet_01v8  w=0.5  l=0.5
X_rhebb_24_9  iwrite_route_24_9  inp_upper_9  ierr_dig_24  vcm_route  vdd vss  hebbian_mult
XMPRED_r_24_10  i_pred_24  vw_route_24_10  vss  vss  sky130_fd_pr__nfet_01v8  w=4  l=0.35
Cw_route_24_10  vw_route_24_10  vss  200f
R_bleed_24_10  vw_route_24_10  vss  10000meg
XMN4_r_24_10  vw_route_24_10  we_route  iwrite_route_24_10  vss  sky130_fd_pr__nfet_01v8  w=0.5  l=0.5
X_rhebb_24_10  iwrite_route_24_10  inp_upper_10  ierr_dig_24  vcm_route  vdd vss  hebbian_mult
XMPRED_r_24_11  i_pred_24  vw_route_24_11  vss  vss  sky130_fd_pr__nfet_01v8  w=4  l=0.35
Cw_route_24_11  vw_route_24_11  vss  200f
R_bleed_24_11  vw_route_24_11  vss  10000meg
XMN4_r_24_11  vw_route_24_11  we_route  iwrite_route_24_11  vss  sky130_fd_pr__nfet_01v8  w=0.5  l=0.5
X_rhebb_24_11  iwrite_route_24_11  inp_upper_11  ierr_dig_24  vcm_route  vdd vss  hebbian_mult
XMPRED_r_24_12  i_pred_24  vw_route_24_12  vss  vss  sky130_fd_pr__nfet_01v8  w=4  l=0.35
Cw_route_24_12  vw_route_24_12  vss  200f
R_bleed_24_12  vw_route_24_12  vss  10000meg
XMN4_r_24_12  vw_route_24_12  we_route  iwrite_route_24_12  vss  sky130_fd_pr__nfet_01v8  w=0.5  l=0.5
X_rhebb_24_12  iwrite_route_24_12  inp_upper_12  ierr_dig_24  vcm_route  vdd vss  hebbian_mult
XMPRED_r_24_13  i_pred_24  vw_route_24_13  vss  vss  sky130_fd_pr__nfet_01v8  w=4  l=0.35
Cw_route_24_13  vw_route_24_13  vss  200f
R_bleed_24_13  vw_route_24_13  vss  10000meg
XMN4_r_24_13  vw_route_24_13  we_route  iwrite_route_24_13  vss  sky130_fd_pr__nfet_01v8  w=0.5  l=0.5
X_rhebb_24_13  iwrite_route_24_13  inp_upper_13  ierr_dig_24  vcm_route  vdd vss  hebbian_mult
XMPRED_r_24_14  i_pred_24  vw_route_24_14  vss  vss  sky130_fd_pr__nfet_01v8  w=4  l=0.35
Cw_route_24_14  vw_route_24_14  vss  200f
R_bleed_24_14  vw_route_24_14  vss  10000meg
XMN4_r_24_14  vw_route_24_14  we_route  iwrite_route_24_14  vss  sky130_fd_pr__nfet_01v8  w=0.5  l=0.5
X_rhebb_24_14  iwrite_route_24_14  inp_upper_14  ierr_dig_24  vcm_route  vdd vss  hebbian_mult
XMPRED_r_24_15  i_pred_24  vw_route_24_15  vss  vss  sky130_fd_pr__nfet_01v8  w=4  l=0.35
Cw_route_24_15  vw_route_24_15  vss  200f
R_bleed_24_15  vw_route_24_15  vss  10000meg
XMN4_r_24_15  vw_route_24_15  we_route  iwrite_route_24_15  vss  sky130_fd_pr__nfet_01v8  w=0.5  l=0.5
X_rhebb_24_15  iwrite_route_24_15  inp_upper_15  ierr_dig_24  vcm_route  vdd vss  hebbian_mult
XMPRED_r_24_16  i_pred_24  vw_route_24_16  vss  vss  sky130_fd_pr__nfet_01v8  w=4  l=0.35
Cw_route_24_16  vw_route_24_16  vss  200f
R_bleed_24_16  vw_route_24_16  vss  10000meg
XMN4_r_24_16  vw_route_24_16  we_route  iwrite_route_24_16  vss  sky130_fd_pr__nfet_01v8  w=0.5  l=0.5
X_rhebb_24_16  iwrite_route_24_16  inp_upper_16  ierr_dig_24  vcm_route  vdd vss  hebbian_mult
XMPRED_r_24_17  i_pred_24  vw_route_24_17  vss  vss  sky130_fd_pr__nfet_01v8  w=4  l=0.35
Cw_route_24_17  vw_route_24_17  vss  200f
R_bleed_24_17  vw_route_24_17  vss  10000meg
XMN4_r_24_17  vw_route_24_17  we_route  iwrite_route_24_17  vss  sky130_fd_pr__nfet_01v8  w=0.5  l=0.5
X_rhebb_24_17  iwrite_route_24_17  inp_upper_17  ierr_dig_24  vcm_route  vdd vss  hebbian_mult
XMPRED_r_24_18  i_pred_24  vw_route_24_18  vss  vss  sky130_fd_pr__nfet_01v8  w=4  l=0.35
Cw_route_24_18  vw_route_24_18  vss  200f
R_bleed_24_18  vw_route_24_18  vss  10000meg
XMN4_r_24_18  vw_route_24_18  we_route  iwrite_route_24_18  vss  sky130_fd_pr__nfet_01v8  w=0.5  l=0.5
X_rhebb_24_18  iwrite_route_24_18  inp_upper_18  ierr_dig_24  vcm_route  vdd vss  hebbian_mult
XMPRED_r_24_19  i_pred_24  vw_route_24_19  vss  vss  sky130_fd_pr__nfet_01v8  w=4  l=0.35
Cw_route_24_19  vw_route_24_19  vss  200f
R_bleed_24_19  vw_route_24_19  vss  10000meg
XMN4_r_24_19  vw_route_24_19  we_route  iwrite_route_24_19  vss  sky130_fd_pr__nfet_01v8  w=0.5  l=0.5
X_rhebb_24_19  iwrite_route_24_19  inp_upper_19  ierr_dig_24  vcm_route  vdd vss  hebbian_mult
XMPRED_r_24_20  i_pred_24  vw_route_24_20  vss  vss  sky130_fd_pr__nfet_01v8  w=4  l=0.35
Cw_route_24_20  vw_route_24_20  vss  200f
R_bleed_24_20  vw_route_24_20  vss  10000meg
XMN4_r_24_20  vw_route_24_20  we_route  iwrite_route_24_20  vss  sky130_fd_pr__nfet_01v8  w=0.5  l=0.5
X_rhebb_24_20  iwrite_route_24_20  inp_upper_20  ierr_dig_24  vcm_route  vdd vss  hebbian_mult
XMPRED_r_24_21  i_pred_24  vw_route_24_21  vss  vss  sky130_fd_pr__nfet_01v8  w=4  l=0.35
Cw_route_24_21  vw_route_24_21  vss  200f
R_bleed_24_21  vw_route_24_21  vss  10000meg
XMN4_r_24_21  vw_route_24_21  we_route  iwrite_route_24_21  vss  sky130_fd_pr__nfet_01v8  w=0.5  l=0.5
X_rhebb_24_21  iwrite_route_24_21  inp_upper_21  ierr_dig_24  vcm_route  vdd vss  hebbian_mult
XMPRED_r_24_22  i_pred_24  vw_route_24_22  vss  vss  sky130_fd_pr__nfet_01v8  w=4  l=0.35
Cw_route_24_22  vw_route_24_22  vss  200f
R_bleed_24_22  vw_route_24_22  vss  10000meg
XMN4_r_24_22  vw_route_24_22  we_route  iwrite_route_24_22  vss  sky130_fd_pr__nfet_01v8  w=0.5  l=0.5
X_rhebb_24_22  iwrite_route_24_22  inp_upper_22  ierr_dig_24  vcm_route  vdd vss  hebbian_mult
XMPRED_r_24_23  i_pred_24  vw_route_24_23  vss  vss  sky130_fd_pr__nfet_01v8  w=4  l=0.35
Cw_route_24_23  vw_route_24_23  vss  200f
R_bleed_24_23  vw_route_24_23  vss  10000meg
XMN4_r_24_23  vw_route_24_23  we_route  iwrite_route_24_23  vss  sky130_fd_pr__nfet_01v8  w=0.5  l=0.5
X_rhebb_24_23  iwrite_route_24_23  inp_upper_23  ierr_dig_24  vcm_route  vdd vss  hebbian_mult
XMPRED_r_24_24  i_pred_24  vw_route_24_24  vss  vss  sky130_fd_pr__nfet_01v8  w=4  l=0.35
Cw_route_24_24  vw_route_24_24  vss  200f
R_bleed_24_24  vw_route_24_24  vss  10000meg
XMN4_r_24_24  vw_route_24_24  we_route  iwrite_route_24_24  vss  sky130_fd_pr__nfet_01v8  w=0.5  l=0.5
X_rhebb_24_24  iwrite_route_24_24  inp_upper_24  ierr_dig_24  vcm_route  vdd vss  hebbian_mult
XMPRED_r_24_25  i_pred_24  vw_route_24_25  vss  vss  sky130_fd_pr__nfet_01v8  w=4  l=0.35
Cw_route_24_25  vw_route_24_25  vss  200f
R_bleed_24_25  vw_route_24_25  vss  10000meg
XMN4_r_24_25  vw_route_24_25  we_route  iwrite_route_24_25  vss  sky130_fd_pr__nfet_01v8  w=0.5  l=0.5
X_rhebb_24_25  iwrite_route_24_25  inp_upper_25  ierr_dig_24  vcm_route  vdd vss  hebbian_mult
XMPRED_r_24_26  i_pred_24  vw_route_24_26  vss  vss  sky130_fd_pr__nfet_01v8  w=4  l=0.35
Cw_route_24_26  vw_route_24_26  vss  200f
R_bleed_24_26  vw_route_24_26  vss  10000meg
XMN4_r_24_26  vw_route_24_26  we_route  iwrite_route_24_26  vss  sky130_fd_pr__nfet_01v8  w=0.5  l=0.5
X_rhebb_24_26  iwrite_route_24_26  inp_upper_26  ierr_dig_24  vcm_route  vdd vss  hebbian_mult
XMPRED_r_24_27  i_pred_24  vw_route_24_27  vss  vss  sky130_fd_pr__nfet_01v8  w=4  l=0.35
Cw_route_24_27  vw_route_24_27  vss  200f
R_bleed_24_27  vw_route_24_27  vss  10000meg
XMN4_r_24_27  vw_route_24_27  we_route  iwrite_route_24_27  vss  sky130_fd_pr__nfet_01v8  w=0.5  l=0.5
X_rhebb_24_27  iwrite_route_24_27  inp_upper_27  ierr_dig_24  vcm_route  vdd vss  hebbian_mult
XMPRED_r_24_28  i_pred_24  vw_route_24_28  vss  vss  sky130_fd_pr__nfet_01v8  w=4  l=0.35
Cw_route_24_28  vw_route_24_28  vss  200f
R_bleed_24_28  vw_route_24_28  vss  10000meg
XMN4_r_24_28  vw_route_24_28  we_route  iwrite_route_24_28  vss  sky130_fd_pr__nfet_01v8  w=0.5  l=0.5
X_rhebb_24_28  iwrite_route_24_28  inp_upper_28  ierr_dig_24  vcm_route  vdd vss  hebbian_mult
XMPRED_r_24_29  i_pred_24  vw_route_24_29  vss  vss  sky130_fd_pr__nfet_01v8  w=4  l=0.35
Cw_route_24_29  vw_route_24_29  vss  200f
R_bleed_24_29  vw_route_24_29  vss  10000meg
XMN4_r_24_29  vw_route_24_29  we_route  iwrite_route_24_29  vss  sky130_fd_pr__nfet_01v8  w=0.5  l=0.5
X_rhebb_24_29  iwrite_route_24_29  inp_upper_29  ierr_dig_24  vcm_route  vdd vss  hebbian_mult
XMPRED_r_24_30  i_pred_24  vw_route_24_30  vss  vss  sky130_fd_pr__nfet_01v8  w=4  l=0.35
Cw_route_24_30  vw_route_24_30  vss  200f
R_bleed_24_30  vw_route_24_30  vss  10000meg
XMN4_r_24_30  vw_route_24_30  we_route  iwrite_route_24_30  vss  sky130_fd_pr__nfet_01v8  w=0.5  l=0.5
X_rhebb_24_30  iwrite_route_24_30  inp_upper_30  ierr_dig_24  vcm_route  vdd vss  hebbian_mult
XMPRED_r_24_31  i_pred_24  vw_route_24_31  vss  vss  sky130_fd_pr__nfet_01v8  w=4  l=0.35
Cw_route_24_31  vw_route_24_31  vss  200f
R_bleed_24_31  vw_route_24_31  vss  10000meg
XMN4_r_24_31  vw_route_24_31  we_route  iwrite_route_24_31  vss  sky130_fd_pr__nfet_01v8  w=0.5  l=0.5
X_rhebb_24_31  iwrite_route_24_31  inp_upper_31  ierr_dig_24  vcm_route  vdd vss  hebbian_mult

* ── Destination row 25 ── 32 source connections ──────────────────────────
XMPRED_r_25_0  i_pred_25  vw_route_25_0  vss  vss  sky130_fd_pr__nfet_01v8  w=4  l=0.35
Cw_route_25_0  vw_route_25_0  vss  200f
R_bleed_25_0  vw_route_25_0  vss  10000meg
XMN4_r_25_0  vw_route_25_0  we_route  iwrite_route_25_0  vss  sky130_fd_pr__nfet_01v8  w=0.5  l=0.5
X_rhebb_25_0  iwrite_route_25_0  inp_upper_0  ierr_dig_25  vcm_route  vdd vss  hebbian_mult
XMPRED_r_25_1  i_pred_25  vw_route_25_1  vss  vss  sky130_fd_pr__nfet_01v8  w=4  l=0.35
Cw_route_25_1  vw_route_25_1  vss  200f
R_bleed_25_1  vw_route_25_1  vss  10000meg
XMN4_r_25_1  vw_route_25_1  we_route  iwrite_route_25_1  vss  sky130_fd_pr__nfet_01v8  w=0.5  l=0.5
X_rhebb_25_1  iwrite_route_25_1  inp_upper_1  ierr_dig_25  vcm_route  vdd vss  hebbian_mult
XMPRED_r_25_2  i_pred_25  vw_route_25_2  vss  vss  sky130_fd_pr__nfet_01v8  w=4  l=0.35
Cw_route_25_2  vw_route_25_2  vss  200f
R_bleed_25_2  vw_route_25_2  vss  10000meg
XMN4_r_25_2  vw_route_25_2  we_route  iwrite_route_25_2  vss  sky130_fd_pr__nfet_01v8  w=0.5  l=0.5
X_rhebb_25_2  iwrite_route_25_2  inp_upper_2  ierr_dig_25  vcm_route  vdd vss  hebbian_mult
XMPRED_r_25_3  i_pred_25  vw_route_25_3  vss  vss  sky130_fd_pr__nfet_01v8  w=4  l=0.35
Cw_route_25_3  vw_route_25_3  vss  200f
R_bleed_25_3  vw_route_25_3  vss  10000meg
XMN4_r_25_3  vw_route_25_3  we_route  iwrite_route_25_3  vss  sky130_fd_pr__nfet_01v8  w=0.5  l=0.5
X_rhebb_25_3  iwrite_route_25_3  inp_upper_3  ierr_dig_25  vcm_route  vdd vss  hebbian_mult
XMPRED_r_25_4  i_pred_25  vw_route_25_4  vss  vss  sky130_fd_pr__nfet_01v8  w=4  l=0.35
Cw_route_25_4  vw_route_25_4  vss  200f
R_bleed_25_4  vw_route_25_4  vss  10000meg
XMN4_r_25_4  vw_route_25_4  we_route  iwrite_route_25_4  vss  sky130_fd_pr__nfet_01v8  w=0.5  l=0.5
X_rhebb_25_4  iwrite_route_25_4  inp_upper_4  ierr_dig_25  vcm_route  vdd vss  hebbian_mult
XMPRED_r_25_5  i_pred_25  vw_route_25_5  vss  vss  sky130_fd_pr__nfet_01v8  w=4  l=0.35
Cw_route_25_5  vw_route_25_5  vss  200f
R_bleed_25_5  vw_route_25_5  vss  10000meg
XMN4_r_25_5  vw_route_25_5  we_route  iwrite_route_25_5  vss  sky130_fd_pr__nfet_01v8  w=0.5  l=0.5
X_rhebb_25_5  iwrite_route_25_5  inp_upper_5  ierr_dig_25  vcm_route  vdd vss  hebbian_mult
XMPRED_r_25_6  i_pred_25  vw_route_25_6  vss  vss  sky130_fd_pr__nfet_01v8  w=4  l=0.35
Cw_route_25_6  vw_route_25_6  vss  200f
R_bleed_25_6  vw_route_25_6  vss  10000meg
XMN4_r_25_6  vw_route_25_6  we_route  iwrite_route_25_6  vss  sky130_fd_pr__nfet_01v8  w=0.5  l=0.5
X_rhebb_25_6  iwrite_route_25_6  inp_upper_6  ierr_dig_25  vcm_route  vdd vss  hebbian_mult
XMPRED_r_25_7  i_pred_25  vw_route_25_7  vss  vss  sky130_fd_pr__nfet_01v8  w=4  l=0.35
Cw_route_25_7  vw_route_25_7  vss  200f
R_bleed_25_7  vw_route_25_7  vss  10000meg
XMN4_r_25_7  vw_route_25_7  we_route  iwrite_route_25_7  vss  sky130_fd_pr__nfet_01v8  w=0.5  l=0.5
X_rhebb_25_7  iwrite_route_25_7  inp_upper_7  ierr_dig_25  vcm_route  vdd vss  hebbian_mult
XMPRED_r_25_8  i_pred_25  vw_route_25_8  vss  vss  sky130_fd_pr__nfet_01v8  w=4  l=0.35
Cw_route_25_8  vw_route_25_8  vss  200f
R_bleed_25_8  vw_route_25_8  vss  10000meg
XMN4_r_25_8  vw_route_25_8  we_route  iwrite_route_25_8  vss  sky130_fd_pr__nfet_01v8  w=0.5  l=0.5
X_rhebb_25_8  iwrite_route_25_8  inp_upper_8  ierr_dig_25  vcm_route  vdd vss  hebbian_mult
XMPRED_r_25_9  i_pred_25  vw_route_25_9  vss  vss  sky130_fd_pr__nfet_01v8  w=4  l=0.35
Cw_route_25_9  vw_route_25_9  vss  200f
R_bleed_25_9  vw_route_25_9  vss  10000meg
XMN4_r_25_9  vw_route_25_9  we_route  iwrite_route_25_9  vss  sky130_fd_pr__nfet_01v8  w=0.5  l=0.5
X_rhebb_25_9  iwrite_route_25_9  inp_upper_9  ierr_dig_25  vcm_route  vdd vss  hebbian_mult
XMPRED_r_25_10  i_pred_25  vw_route_25_10  vss  vss  sky130_fd_pr__nfet_01v8  w=4  l=0.35
Cw_route_25_10  vw_route_25_10  vss  200f
R_bleed_25_10  vw_route_25_10  vss  10000meg
XMN4_r_25_10  vw_route_25_10  we_route  iwrite_route_25_10  vss  sky130_fd_pr__nfet_01v8  w=0.5  l=0.5
X_rhebb_25_10  iwrite_route_25_10  inp_upper_10  ierr_dig_25  vcm_route  vdd vss  hebbian_mult
XMPRED_r_25_11  i_pred_25  vw_route_25_11  vss  vss  sky130_fd_pr__nfet_01v8  w=4  l=0.35
Cw_route_25_11  vw_route_25_11  vss  200f
R_bleed_25_11  vw_route_25_11  vss  10000meg
XMN4_r_25_11  vw_route_25_11  we_route  iwrite_route_25_11  vss  sky130_fd_pr__nfet_01v8  w=0.5  l=0.5
X_rhebb_25_11  iwrite_route_25_11  inp_upper_11  ierr_dig_25  vcm_route  vdd vss  hebbian_mult
XMPRED_r_25_12  i_pred_25  vw_route_25_12  vss  vss  sky130_fd_pr__nfet_01v8  w=4  l=0.35
Cw_route_25_12  vw_route_25_12  vss  200f
R_bleed_25_12  vw_route_25_12  vss  10000meg
XMN4_r_25_12  vw_route_25_12  we_route  iwrite_route_25_12  vss  sky130_fd_pr__nfet_01v8  w=0.5  l=0.5
X_rhebb_25_12  iwrite_route_25_12  inp_upper_12  ierr_dig_25  vcm_route  vdd vss  hebbian_mult
XMPRED_r_25_13  i_pred_25  vw_route_25_13  vss  vss  sky130_fd_pr__nfet_01v8  w=4  l=0.35
Cw_route_25_13  vw_route_25_13  vss  200f
R_bleed_25_13  vw_route_25_13  vss  10000meg
XMN4_r_25_13  vw_route_25_13  we_route  iwrite_route_25_13  vss  sky130_fd_pr__nfet_01v8  w=0.5  l=0.5
X_rhebb_25_13  iwrite_route_25_13  inp_upper_13  ierr_dig_25  vcm_route  vdd vss  hebbian_mult
XMPRED_r_25_14  i_pred_25  vw_route_25_14  vss  vss  sky130_fd_pr__nfet_01v8  w=4  l=0.35
Cw_route_25_14  vw_route_25_14  vss  200f
R_bleed_25_14  vw_route_25_14  vss  10000meg
XMN4_r_25_14  vw_route_25_14  we_route  iwrite_route_25_14  vss  sky130_fd_pr__nfet_01v8  w=0.5  l=0.5
X_rhebb_25_14  iwrite_route_25_14  inp_upper_14  ierr_dig_25  vcm_route  vdd vss  hebbian_mult
XMPRED_r_25_15  i_pred_25  vw_route_25_15  vss  vss  sky130_fd_pr__nfet_01v8  w=4  l=0.35
Cw_route_25_15  vw_route_25_15  vss  200f
R_bleed_25_15  vw_route_25_15  vss  10000meg
XMN4_r_25_15  vw_route_25_15  we_route  iwrite_route_25_15  vss  sky130_fd_pr__nfet_01v8  w=0.5  l=0.5
X_rhebb_25_15  iwrite_route_25_15  inp_upper_15  ierr_dig_25  vcm_route  vdd vss  hebbian_mult
XMPRED_r_25_16  i_pred_25  vw_route_25_16  vss  vss  sky130_fd_pr__nfet_01v8  w=4  l=0.35
Cw_route_25_16  vw_route_25_16  vss  200f
R_bleed_25_16  vw_route_25_16  vss  10000meg
XMN4_r_25_16  vw_route_25_16  we_route  iwrite_route_25_16  vss  sky130_fd_pr__nfet_01v8  w=0.5  l=0.5
X_rhebb_25_16  iwrite_route_25_16  inp_upper_16  ierr_dig_25  vcm_route  vdd vss  hebbian_mult
XMPRED_r_25_17  i_pred_25  vw_route_25_17  vss  vss  sky130_fd_pr__nfet_01v8  w=4  l=0.35
Cw_route_25_17  vw_route_25_17  vss  200f
R_bleed_25_17  vw_route_25_17  vss  10000meg
XMN4_r_25_17  vw_route_25_17  we_route  iwrite_route_25_17  vss  sky130_fd_pr__nfet_01v8  w=0.5  l=0.5
X_rhebb_25_17  iwrite_route_25_17  inp_upper_17  ierr_dig_25  vcm_route  vdd vss  hebbian_mult
XMPRED_r_25_18  i_pred_25  vw_route_25_18  vss  vss  sky130_fd_pr__nfet_01v8  w=4  l=0.35
Cw_route_25_18  vw_route_25_18  vss  200f
R_bleed_25_18  vw_route_25_18  vss  10000meg
XMN4_r_25_18  vw_route_25_18  we_route  iwrite_route_25_18  vss  sky130_fd_pr__nfet_01v8  w=0.5  l=0.5
X_rhebb_25_18  iwrite_route_25_18  inp_upper_18  ierr_dig_25  vcm_route  vdd vss  hebbian_mult
XMPRED_r_25_19  i_pred_25  vw_route_25_19  vss  vss  sky130_fd_pr__nfet_01v8  w=4  l=0.35
Cw_route_25_19  vw_route_25_19  vss  200f
R_bleed_25_19  vw_route_25_19  vss  10000meg
XMN4_r_25_19  vw_route_25_19  we_route  iwrite_route_25_19  vss  sky130_fd_pr__nfet_01v8  w=0.5  l=0.5
X_rhebb_25_19  iwrite_route_25_19  inp_upper_19  ierr_dig_25  vcm_route  vdd vss  hebbian_mult
XMPRED_r_25_20  i_pred_25  vw_route_25_20  vss  vss  sky130_fd_pr__nfet_01v8  w=4  l=0.35
Cw_route_25_20  vw_route_25_20  vss  200f
R_bleed_25_20  vw_route_25_20  vss  10000meg
XMN4_r_25_20  vw_route_25_20  we_route  iwrite_route_25_20  vss  sky130_fd_pr__nfet_01v8  w=0.5  l=0.5
X_rhebb_25_20  iwrite_route_25_20  inp_upper_20  ierr_dig_25  vcm_route  vdd vss  hebbian_mult
XMPRED_r_25_21  i_pred_25  vw_route_25_21  vss  vss  sky130_fd_pr__nfet_01v8  w=4  l=0.35
Cw_route_25_21  vw_route_25_21  vss  200f
R_bleed_25_21  vw_route_25_21  vss  10000meg
XMN4_r_25_21  vw_route_25_21  we_route  iwrite_route_25_21  vss  sky130_fd_pr__nfet_01v8  w=0.5  l=0.5
X_rhebb_25_21  iwrite_route_25_21  inp_upper_21  ierr_dig_25  vcm_route  vdd vss  hebbian_mult
XMPRED_r_25_22  i_pred_25  vw_route_25_22  vss  vss  sky130_fd_pr__nfet_01v8  w=4  l=0.35
Cw_route_25_22  vw_route_25_22  vss  200f
R_bleed_25_22  vw_route_25_22  vss  10000meg
XMN4_r_25_22  vw_route_25_22  we_route  iwrite_route_25_22  vss  sky130_fd_pr__nfet_01v8  w=0.5  l=0.5
X_rhebb_25_22  iwrite_route_25_22  inp_upper_22  ierr_dig_25  vcm_route  vdd vss  hebbian_mult
XMPRED_r_25_23  i_pred_25  vw_route_25_23  vss  vss  sky130_fd_pr__nfet_01v8  w=4  l=0.35
Cw_route_25_23  vw_route_25_23  vss  200f
R_bleed_25_23  vw_route_25_23  vss  10000meg
XMN4_r_25_23  vw_route_25_23  we_route  iwrite_route_25_23  vss  sky130_fd_pr__nfet_01v8  w=0.5  l=0.5
X_rhebb_25_23  iwrite_route_25_23  inp_upper_23  ierr_dig_25  vcm_route  vdd vss  hebbian_mult
XMPRED_r_25_24  i_pred_25  vw_route_25_24  vss  vss  sky130_fd_pr__nfet_01v8  w=4  l=0.35
Cw_route_25_24  vw_route_25_24  vss  200f
R_bleed_25_24  vw_route_25_24  vss  10000meg
XMN4_r_25_24  vw_route_25_24  we_route  iwrite_route_25_24  vss  sky130_fd_pr__nfet_01v8  w=0.5  l=0.5
X_rhebb_25_24  iwrite_route_25_24  inp_upper_24  ierr_dig_25  vcm_route  vdd vss  hebbian_mult
XMPRED_r_25_25  i_pred_25  vw_route_25_25  vss  vss  sky130_fd_pr__nfet_01v8  w=4  l=0.35
Cw_route_25_25  vw_route_25_25  vss  200f
R_bleed_25_25  vw_route_25_25  vss  10000meg
XMN4_r_25_25  vw_route_25_25  we_route  iwrite_route_25_25  vss  sky130_fd_pr__nfet_01v8  w=0.5  l=0.5
X_rhebb_25_25  iwrite_route_25_25  inp_upper_25  ierr_dig_25  vcm_route  vdd vss  hebbian_mult
XMPRED_r_25_26  i_pred_25  vw_route_25_26  vss  vss  sky130_fd_pr__nfet_01v8  w=4  l=0.35
Cw_route_25_26  vw_route_25_26  vss  200f
R_bleed_25_26  vw_route_25_26  vss  10000meg
XMN4_r_25_26  vw_route_25_26  we_route  iwrite_route_25_26  vss  sky130_fd_pr__nfet_01v8  w=0.5  l=0.5
X_rhebb_25_26  iwrite_route_25_26  inp_upper_26  ierr_dig_25  vcm_route  vdd vss  hebbian_mult
XMPRED_r_25_27  i_pred_25  vw_route_25_27  vss  vss  sky130_fd_pr__nfet_01v8  w=4  l=0.35
Cw_route_25_27  vw_route_25_27  vss  200f
R_bleed_25_27  vw_route_25_27  vss  10000meg
XMN4_r_25_27  vw_route_25_27  we_route  iwrite_route_25_27  vss  sky130_fd_pr__nfet_01v8  w=0.5  l=0.5
X_rhebb_25_27  iwrite_route_25_27  inp_upper_27  ierr_dig_25  vcm_route  vdd vss  hebbian_mult
XMPRED_r_25_28  i_pred_25  vw_route_25_28  vss  vss  sky130_fd_pr__nfet_01v8  w=4  l=0.35
Cw_route_25_28  vw_route_25_28  vss  200f
R_bleed_25_28  vw_route_25_28  vss  10000meg
XMN4_r_25_28  vw_route_25_28  we_route  iwrite_route_25_28  vss  sky130_fd_pr__nfet_01v8  w=0.5  l=0.5
X_rhebb_25_28  iwrite_route_25_28  inp_upper_28  ierr_dig_25  vcm_route  vdd vss  hebbian_mult
XMPRED_r_25_29  i_pred_25  vw_route_25_29  vss  vss  sky130_fd_pr__nfet_01v8  w=4  l=0.35
Cw_route_25_29  vw_route_25_29  vss  200f
R_bleed_25_29  vw_route_25_29  vss  10000meg
XMN4_r_25_29  vw_route_25_29  we_route  iwrite_route_25_29  vss  sky130_fd_pr__nfet_01v8  w=0.5  l=0.5
X_rhebb_25_29  iwrite_route_25_29  inp_upper_29  ierr_dig_25  vcm_route  vdd vss  hebbian_mult
XMPRED_r_25_30  i_pred_25  vw_route_25_30  vss  vss  sky130_fd_pr__nfet_01v8  w=4  l=0.35
Cw_route_25_30  vw_route_25_30  vss  200f
R_bleed_25_30  vw_route_25_30  vss  10000meg
XMN4_r_25_30  vw_route_25_30  we_route  iwrite_route_25_30  vss  sky130_fd_pr__nfet_01v8  w=0.5  l=0.5
X_rhebb_25_30  iwrite_route_25_30  inp_upper_30  ierr_dig_25  vcm_route  vdd vss  hebbian_mult
XMPRED_r_25_31  i_pred_25  vw_route_25_31  vss  vss  sky130_fd_pr__nfet_01v8  w=4  l=0.35
Cw_route_25_31  vw_route_25_31  vss  200f
R_bleed_25_31  vw_route_25_31  vss  10000meg
XMN4_r_25_31  vw_route_25_31  we_route  iwrite_route_25_31  vss  sky130_fd_pr__nfet_01v8  w=0.5  l=0.5
X_rhebb_25_31  iwrite_route_25_31  inp_upper_31  ierr_dig_25  vcm_route  vdd vss  hebbian_mult

* ── Destination row 26 ── 32 source connections ──────────────────────────
XMPRED_r_26_0  i_pred_26  vw_route_26_0  vss  vss  sky130_fd_pr__nfet_01v8  w=4  l=0.35
Cw_route_26_0  vw_route_26_0  vss  200f
R_bleed_26_0  vw_route_26_0  vss  10000meg
XMN4_r_26_0  vw_route_26_0  we_route  iwrite_route_26_0  vss  sky130_fd_pr__nfet_01v8  w=0.5  l=0.5
X_rhebb_26_0  iwrite_route_26_0  inp_upper_0  ierr_dig_26  vcm_route  vdd vss  hebbian_mult
XMPRED_r_26_1  i_pred_26  vw_route_26_1  vss  vss  sky130_fd_pr__nfet_01v8  w=4  l=0.35
Cw_route_26_1  vw_route_26_1  vss  200f
R_bleed_26_1  vw_route_26_1  vss  10000meg
XMN4_r_26_1  vw_route_26_1  we_route  iwrite_route_26_1  vss  sky130_fd_pr__nfet_01v8  w=0.5  l=0.5
X_rhebb_26_1  iwrite_route_26_1  inp_upper_1  ierr_dig_26  vcm_route  vdd vss  hebbian_mult
XMPRED_r_26_2  i_pred_26  vw_route_26_2  vss  vss  sky130_fd_pr__nfet_01v8  w=4  l=0.35
Cw_route_26_2  vw_route_26_2  vss  200f
R_bleed_26_2  vw_route_26_2  vss  10000meg
XMN4_r_26_2  vw_route_26_2  we_route  iwrite_route_26_2  vss  sky130_fd_pr__nfet_01v8  w=0.5  l=0.5
X_rhebb_26_2  iwrite_route_26_2  inp_upper_2  ierr_dig_26  vcm_route  vdd vss  hebbian_mult
XMPRED_r_26_3  i_pred_26  vw_route_26_3  vss  vss  sky130_fd_pr__nfet_01v8  w=4  l=0.35
Cw_route_26_3  vw_route_26_3  vss  200f
R_bleed_26_3  vw_route_26_3  vss  10000meg
XMN4_r_26_3  vw_route_26_3  we_route  iwrite_route_26_3  vss  sky130_fd_pr__nfet_01v8  w=0.5  l=0.5
X_rhebb_26_3  iwrite_route_26_3  inp_upper_3  ierr_dig_26  vcm_route  vdd vss  hebbian_mult
XMPRED_r_26_4  i_pred_26  vw_route_26_4  vss  vss  sky130_fd_pr__nfet_01v8  w=4  l=0.35
Cw_route_26_4  vw_route_26_4  vss  200f
R_bleed_26_4  vw_route_26_4  vss  10000meg
XMN4_r_26_4  vw_route_26_4  we_route  iwrite_route_26_4  vss  sky130_fd_pr__nfet_01v8  w=0.5  l=0.5
X_rhebb_26_4  iwrite_route_26_4  inp_upper_4  ierr_dig_26  vcm_route  vdd vss  hebbian_mult
XMPRED_r_26_5  i_pred_26  vw_route_26_5  vss  vss  sky130_fd_pr__nfet_01v8  w=4  l=0.35
Cw_route_26_5  vw_route_26_5  vss  200f
R_bleed_26_5  vw_route_26_5  vss  10000meg
XMN4_r_26_5  vw_route_26_5  we_route  iwrite_route_26_5  vss  sky130_fd_pr__nfet_01v8  w=0.5  l=0.5
X_rhebb_26_5  iwrite_route_26_5  inp_upper_5  ierr_dig_26  vcm_route  vdd vss  hebbian_mult
XMPRED_r_26_6  i_pred_26  vw_route_26_6  vss  vss  sky130_fd_pr__nfet_01v8  w=4  l=0.35
Cw_route_26_6  vw_route_26_6  vss  200f
R_bleed_26_6  vw_route_26_6  vss  10000meg
XMN4_r_26_6  vw_route_26_6  we_route  iwrite_route_26_6  vss  sky130_fd_pr__nfet_01v8  w=0.5  l=0.5
X_rhebb_26_6  iwrite_route_26_6  inp_upper_6  ierr_dig_26  vcm_route  vdd vss  hebbian_mult
XMPRED_r_26_7  i_pred_26  vw_route_26_7  vss  vss  sky130_fd_pr__nfet_01v8  w=4  l=0.35
Cw_route_26_7  vw_route_26_7  vss  200f
R_bleed_26_7  vw_route_26_7  vss  10000meg
XMN4_r_26_7  vw_route_26_7  we_route  iwrite_route_26_7  vss  sky130_fd_pr__nfet_01v8  w=0.5  l=0.5
X_rhebb_26_7  iwrite_route_26_7  inp_upper_7  ierr_dig_26  vcm_route  vdd vss  hebbian_mult
XMPRED_r_26_8  i_pred_26  vw_route_26_8  vss  vss  sky130_fd_pr__nfet_01v8  w=4  l=0.35
Cw_route_26_8  vw_route_26_8  vss  200f
R_bleed_26_8  vw_route_26_8  vss  10000meg
XMN4_r_26_8  vw_route_26_8  we_route  iwrite_route_26_8  vss  sky130_fd_pr__nfet_01v8  w=0.5  l=0.5
X_rhebb_26_8  iwrite_route_26_8  inp_upper_8  ierr_dig_26  vcm_route  vdd vss  hebbian_mult
XMPRED_r_26_9  i_pred_26  vw_route_26_9  vss  vss  sky130_fd_pr__nfet_01v8  w=4  l=0.35
Cw_route_26_9  vw_route_26_9  vss  200f
R_bleed_26_9  vw_route_26_9  vss  10000meg
XMN4_r_26_9  vw_route_26_9  we_route  iwrite_route_26_9  vss  sky130_fd_pr__nfet_01v8  w=0.5  l=0.5
X_rhebb_26_9  iwrite_route_26_9  inp_upper_9  ierr_dig_26  vcm_route  vdd vss  hebbian_mult
XMPRED_r_26_10  i_pred_26  vw_route_26_10  vss  vss  sky130_fd_pr__nfet_01v8  w=4  l=0.35
Cw_route_26_10  vw_route_26_10  vss  200f
R_bleed_26_10  vw_route_26_10  vss  10000meg
XMN4_r_26_10  vw_route_26_10  we_route  iwrite_route_26_10  vss  sky130_fd_pr__nfet_01v8  w=0.5  l=0.5
X_rhebb_26_10  iwrite_route_26_10  inp_upper_10  ierr_dig_26  vcm_route  vdd vss  hebbian_mult
XMPRED_r_26_11  i_pred_26  vw_route_26_11  vss  vss  sky130_fd_pr__nfet_01v8  w=4  l=0.35
Cw_route_26_11  vw_route_26_11  vss  200f
R_bleed_26_11  vw_route_26_11  vss  10000meg
XMN4_r_26_11  vw_route_26_11  we_route  iwrite_route_26_11  vss  sky130_fd_pr__nfet_01v8  w=0.5  l=0.5
X_rhebb_26_11  iwrite_route_26_11  inp_upper_11  ierr_dig_26  vcm_route  vdd vss  hebbian_mult
XMPRED_r_26_12  i_pred_26  vw_route_26_12  vss  vss  sky130_fd_pr__nfet_01v8  w=4  l=0.35
Cw_route_26_12  vw_route_26_12  vss  200f
R_bleed_26_12  vw_route_26_12  vss  10000meg
XMN4_r_26_12  vw_route_26_12  we_route  iwrite_route_26_12  vss  sky130_fd_pr__nfet_01v8  w=0.5  l=0.5
X_rhebb_26_12  iwrite_route_26_12  inp_upper_12  ierr_dig_26  vcm_route  vdd vss  hebbian_mult
XMPRED_r_26_13  i_pred_26  vw_route_26_13  vss  vss  sky130_fd_pr__nfet_01v8  w=4  l=0.35
Cw_route_26_13  vw_route_26_13  vss  200f
R_bleed_26_13  vw_route_26_13  vss  10000meg
XMN4_r_26_13  vw_route_26_13  we_route  iwrite_route_26_13  vss  sky130_fd_pr__nfet_01v8  w=0.5  l=0.5
X_rhebb_26_13  iwrite_route_26_13  inp_upper_13  ierr_dig_26  vcm_route  vdd vss  hebbian_mult
XMPRED_r_26_14  i_pred_26  vw_route_26_14  vss  vss  sky130_fd_pr__nfet_01v8  w=4  l=0.35
Cw_route_26_14  vw_route_26_14  vss  200f
R_bleed_26_14  vw_route_26_14  vss  10000meg
XMN4_r_26_14  vw_route_26_14  we_route  iwrite_route_26_14  vss  sky130_fd_pr__nfet_01v8  w=0.5  l=0.5
X_rhebb_26_14  iwrite_route_26_14  inp_upper_14  ierr_dig_26  vcm_route  vdd vss  hebbian_mult
XMPRED_r_26_15  i_pred_26  vw_route_26_15  vss  vss  sky130_fd_pr__nfet_01v8  w=4  l=0.35
Cw_route_26_15  vw_route_26_15  vss  200f
R_bleed_26_15  vw_route_26_15  vss  10000meg
XMN4_r_26_15  vw_route_26_15  we_route  iwrite_route_26_15  vss  sky130_fd_pr__nfet_01v8  w=0.5  l=0.5
X_rhebb_26_15  iwrite_route_26_15  inp_upper_15  ierr_dig_26  vcm_route  vdd vss  hebbian_mult
XMPRED_r_26_16  i_pred_26  vw_route_26_16  vss  vss  sky130_fd_pr__nfet_01v8  w=4  l=0.35
Cw_route_26_16  vw_route_26_16  vss  200f
R_bleed_26_16  vw_route_26_16  vss  10000meg
XMN4_r_26_16  vw_route_26_16  we_route  iwrite_route_26_16  vss  sky130_fd_pr__nfet_01v8  w=0.5  l=0.5
X_rhebb_26_16  iwrite_route_26_16  inp_upper_16  ierr_dig_26  vcm_route  vdd vss  hebbian_mult
XMPRED_r_26_17  i_pred_26  vw_route_26_17  vss  vss  sky130_fd_pr__nfet_01v8  w=4  l=0.35
Cw_route_26_17  vw_route_26_17  vss  200f
R_bleed_26_17  vw_route_26_17  vss  10000meg
XMN4_r_26_17  vw_route_26_17  we_route  iwrite_route_26_17  vss  sky130_fd_pr__nfet_01v8  w=0.5  l=0.5
X_rhebb_26_17  iwrite_route_26_17  inp_upper_17  ierr_dig_26  vcm_route  vdd vss  hebbian_mult
XMPRED_r_26_18  i_pred_26  vw_route_26_18  vss  vss  sky130_fd_pr__nfet_01v8  w=4  l=0.35
Cw_route_26_18  vw_route_26_18  vss  200f
R_bleed_26_18  vw_route_26_18  vss  10000meg
XMN4_r_26_18  vw_route_26_18  we_route  iwrite_route_26_18  vss  sky130_fd_pr__nfet_01v8  w=0.5  l=0.5
X_rhebb_26_18  iwrite_route_26_18  inp_upper_18  ierr_dig_26  vcm_route  vdd vss  hebbian_mult
XMPRED_r_26_19  i_pred_26  vw_route_26_19  vss  vss  sky130_fd_pr__nfet_01v8  w=4  l=0.35
Cw_route_26_19  vw_route_26_19  vss  200f
R_bleed_26_19  vw_route_26_19  vss  10000meg
XMN4_r_26_19  vw_route_26_19  we_route  iwrite_route_26_19  vss  sky130_fd_pr__nfet_01v8  w=0.5  l=0.5
X_rhebb_26_19  iwrite_route_26_19  inp_upper_19  ierr_dig_26  vcm_route  vdd vss  hebbian_mult
XMPRED_r_26_20  i_pred_26  vw_route_26_20  vss  vss  sky130_fd_pr__nfet_01v8  w=4  l=0.35
Cw_route_26_20  vw_route_26_20  vss  200f
R_bleed_26_20  vw_route_26_20  vss  10000meg
XMN4_r_26_20  vw_route_26_20  we_route  iwrite_route_26_20  vss  sky130_fd_pr__nfet_01v8  w=0.5  l=0.5
X_rhebb_26_20  iwrite_route_26_20  inp_upper_20  ierr_dig_26  vcm_route  vdd vss  hebbian_mult
XMPRED_r_26_21  i_pred_26  vw_route_26_21  vss  vss  sky130_fd_pr__nfet_01v8  w=4  l=0.35
Cw_route_26_21  vw_route_26_21  vss  200f
R_bleed_26_21  vw_route_26_21  vss  10000meg
XMN4_r_26_21  vw_route_26_21  we_route  iwrite_route_26_21  vss  sky130_fd_pr__nfet_01v8  w=0.5  l=0.5
X_rhebb_26_21  iwrite_route_26_21  inp_upper_21  ierr_dig_26  vcm_route  vdd vss  hebbian_mult
XMPRED_r_26_22  i_pred_26  vw_route_26_22  vss  vss  sky130_fd_pr__nfet_01v8  w=4  l=0.35
Cw_route_26_22  vw_route_26_22  vss  200f
R_bleed_26_22  vw_route_26_22  vss  10000meg
XMN4_r_26_22  vw_route_26_22  we_route  iwrite_route_26_22  vss  sky130_fd_pr__nfet_01v8  w=0.5  l=0.5
X_rhebb_26_22  iwrite_route_26_22  inp_upper_22  ierr_dig_26  vcm_route  vdd vss  hebbian_mult
XMPRED_r_26_23  i_pred_26  vw_route_26_23  vss  vss  sky130_fd_pr__nfet_01v8  w=4  l=0.35
Cw_route_26_23  vw_route_26_23  vss  200f
R_bleed_26_23  vw_route_26_23  vss  10000meg
XMN4_r_26_23  vw_route_26_23  we_route  iwrite_route_26_23  vss  sky130_fd_pr__nfet_01v8  w=0.5  l=0.5
X_rhebb_26_23  iwrite_route_26_23  inp_upper_23  ierr_dig_26  vcm_route  vdd vss  hebbian_mult
XMPRED_r_26_24  i_pred_26  vw_route_26_24  vss  vss  sky130_fd_pr__nfet_01v8  w=4  l=0.35
Cw_route_26_24  vw_route_26_24  vss  200f
R_bleed_26_24  vw_route_26_24  vss  10000meg
XMN4_r_26_24  vw_route_26_24  we_route  iwrite_route_26_24  vss  sky130_fd_pr__nfet_01v8  w=0.5  l=0.5
X_rhebb_26_24  iwrite_route_26_24  inp_upper_24  ierr_dig_26  vcm_route  vdd vss  hebbian_mult
XMPRED_r_26_25  i_pred_26  vw_route_26_25  vss  vss  sky130_fd_pr__nfet_01v8  w=4  l=0.35
Cw_route_26_25  vw_route_26_25  vss  200f
R_bleed_26_25  vw_route_26_25  vss  10000meg
XMN4_r_26_25  vw_route_26_25  we_route  iwrite_route_26_25  vss  sky130_fd_pr__nfet_01v8  w=0.5  l=0.5
X_rhebb_26_25  iwrite_route_26_25  inp_upper_25  ierr_dig_26  vcm_route  vdd vss  hebbian_mult
XMPRED_r_26_26  i_pred_26  vw_route_26_26  vss  vss  sky130_fd_pr__nfet_01v8  w=4  l=0.35
Cw_route_26_26  vw_route_26_26  vss  200f
R_bleed_26_26  vw_route_26_26  vss  10000meg
XMN4_r_26_26  vw_route_26_26  we_route  iwrite_route_26_26  vss  sky130_fd_pr__nfet_01v8  w=0.5  l=0.5
X_rhebb_26_26  iwrite_route_26_26  inp_upper_26  ierr_dig_26  vcm_route  vdd vss  hebbian_mult
XMPRED_r_26_27  i_pred_26  vw_route_26_27  vss  vss  sky130_fd_pr__nfet_01v8  w=4  l=0.35
Cw_route_26_27  vw_route_26_27  vss  200f
R_bleed_26_27  vw_route_26_27  vss  10000meg
XMN4_r_26_27  vw_route_26_27  we_route  iwrite_route_26_27  vss  sky130_fd_pr__nfet_01v8  w=0.5  l=0.5
X_rhebb_26_27  iwrite_route_26_27  inp_upper_27  ierr_dig_26  vcm_route  vdd vss  hebbian_mult
XMPRED_r_26_28  i_pred_26  vw_route_26_28  vss  vss  sky130_fd_pr__nfet_01v8  w=4  l=0.35
Cw_route_26_28  vw_route_26_28  vss  200f
R_bleed_26_28  vw_route_26_28  vss  10000meg
XMN4_r_26_28  vw_route_26_28  we_route  iwrite_route_26_28  vss  sky130_fd_pr__nfet_01v8  w=0.5  l=0.5
X_rhebb_26_28  iwrite_route_26_28  inp_upper_28  ierr_dig_26  vcm_route  vdd vss  hebbian_mult
XMPRED_r_26_29  i_pred_26  vw_route_26_29  vss  vss  sky130_fd_pr__nfet_01v8  w=4  l=0.35
Cw_route_26_29  vw_route_26_29  vss  200f
R_bleed_26_29  vw_route_26_29  vss  10000meg
XMN4_r_26_29  vw_route_26_29  we_route  iwrite_route_26_29  vss  sky130_fd_pr__nfet_01v8  w=0.5  l=0.5
X_rhebb_26_29  iwrite_route_26_29  inp_upper_29  ierr_dig_26  vcm_route  vdd vss  hebbian_mult
XMPRED_r_26_30  i_pred_26  vw_route_26_30  vss  vss  sky130_fd_pr__nfet_01v8  w=4  l=0.35
Cw_route_26_30  vw_route_26_30  vss  200f
R_bleed_26_30  vw_route_26_30  vss  10000meg
XMN4_r_26_30  vw_route_26_30  we_route  iwrite_route_26_30  vss  sky130_fd_pr__nfet_01v8  w=0.5  l=0.5
X_rhebb_26_30  iwrite_route_26_30  inp_upper_30  ierr_dig_26  vcm_route  vdd vss  hebbian_mult
XMPRED_r_26_31  i_pred_26  vw_route_26_31  vss  vss  sky130_fd_pr__nfet_01v8  w=4  l=0.35
Cw_route_26_31  vw_route_26_31  vss  200f
R_bleed_26_31  vw_route_26_31  vss  10000meg
XMN4_r_26_31  vw_route_26_31  we_route  iwrite_route_26_31  vss  sky130_fd_pr__nfet_01v8  w=0.5  l=0.5
X_rhebb_26_31  iwrite_route_26_31  inp_upper_31  ierr_dig_26  vcm_route  vdd vss  hebbian_mult

* ── Destination row 27 ── 32 source connections ──────────────────────────
XMPRED_r_27_0  i_pred_27  vw_route_27_0  vss  vss  sky130_fd_pr__nfet_01v8  w=4  l=0.35
Cw_route_27_0  vw_route_27_0  vss  200f
R_bleed_27_0  vw_route_27_0  vss  10000meg
XMN4_r_27_0  vw_route_27_0  we_route  iwrite_route_27_0  vss  sky130_fd_pr__nfet_01v8  w=0.5  l=0.5
X_rhebb_27_0  iwrite_route_27_0  inp_upper_0  ierr_dig_27  vcm_route  vdd vss  hebbian_mult
XMPRED_r_27_1  i_pred_27  vw_route_27_1  vss  vss  sky130_fd_pr__nfet_01v8  w=4  l=0.35
Cw_route_27_1  vw_route_27_1  vss  200f
R_bleed_27_1  vw_route_27_1  vss  10000meg
XMN4_r_27_1  vw_route_27_1  we_route  iwrite_route_27_1  vss  sky130_fd_pr__nfet_01v8  w=0.5  l=0.5
X_rhebb_27_1  iwrite_route_27_1  inp_upper_1  ierr_dig_27  vcm_route  vdd vss  hebbian_mult
XMPRED_r_27_2  i_pred_27  vw_route_27_2  vss  vss  sky130_fd_pr__nfet_01v8  w=4  l=0.35
Cw_route_27_2  vw_route_27_2  vss  200f
R_bleed_27_2  vw_route_27_2  vss  10000meg
XMN4_r_27_2  vw_route_27_2  we_route  iwrite_route_27_2  vss  sky130_fd_pr__nfet_01v8  w=0.5  l=0.5
X_rhebb_27_2  iwrite_route_27_2  inp_upper_2  ierr_dig_27  vcm_route  vdd vss  hebbian_mult
XMPRED_r_27_3  i_pred_27  vw_route_27_3  vss  vss  sky130_fd_pr__nfet_01v8  w=4  l=0.35
Cw_route_27_3  vw_route_27_3  vss  200f
R_bleed_27_3  vw_route_27_3  vss  10000meg
XMN4_r_27_3  vw_route_27_3  we_route  iwrite_route_27_3  vss  sky130_fd_pr__nfet_01v8  w=0.5  l=0.5
X_rhebb_27_3  iwrite_route_27_3  inp_upper_3  ierr_dig_27  vcm_route  vdd vss  hebbian_mult
XMPRED_r_27_4  i_pred_27  vw_route_27_4  vss  vss  sky130_fd_pr__nfet_01v8  w=4  l=0.35
Cw_route_27_4  vw_route_27_4  vss  200f
R_bleed_27_4  vw_route_27_4  vss  10000meg
XMN4_r_27_4  vw_route_27_4  we_route  iwrite_route_27_4  vss  sky130_fd_pr__nfet_01v8  w=0.5  l=0.5
X_rhebb_27_4  iwrite_route_27_4  inp_upper_4  ierr_dig_27  vcm_route  vdd vss  hebbian_mult
XMPRED_r_27_5  i_pred_27  vw_route_27_5  vss  vss  sky130_fd_pr__nfet_01v8  w=4  l=0.35
Cw_route_27_5  vw_route_27_5  vss  200f
R_bleed_27_5  vw_route_27_5  vss  10000meg
XMN4_r_27_5  vw_route_27_5  we_route  iwrite_route_27_5  vss  sky130_fd_pr__nfet_01v8  w=0.5  l=0.5
X_rhebb_27_5  iwrite_route_27_5  inp_upper_5  ierr_dig_27  vcm_route  vdd vss  hebbian_mult
XMPRED_r_27_6  i_pred_27  vw_route_27_6  vss  vss  sky130_fd_pr__nfet_01v8  w=4  l=0.35
Cw_route_27_6  vw_route_27_6  vss  200f
R_bleed_27_6  vw_route_27_6  vss  10000meg
XMN4_r_27_6  vw_route_27_6  we_route  iwrite_route_27_6  vss  sky130_fd_pr__nfet_01v8  w=0.5  l=0.5
X_rhebb_27_6  iwrite_route_27_6  inp_upper_6  ierr_dig_27  vcm_route  vdd vss  hebbian_mult
XMPRED_r_27_7  i_pred_27  vw_route_27_7  vss  vss  sky130_fd_pr__nfet_01v8  w=4  l=0.35
Cw_route_27_7  vw_route_27_7  vss  200f
R_bleed_27_7  vw_route_27_7  vss  10000meg
XMN4_r_27_7  vw_route_27_7  we_route  iwrite_route_27_7  vss  sky130_fd_pr__nfet_01v8  w=0.5  l=0.5
X_rhebb_27_7  iwrite_route_27_7  inp_upper_7  ierr_dig_27  vcm_route  vdd vss  hebbian_mult
XMPRED_r_27_8  i_pred_27  vw_route_27_8  vss  vss  sky130_fd_pr__nfet_01v8  w=4  l=0.35
Cw_route_27_8  vw_route_27_8  vss  200f
R_bleed_27_8  vw_route_27_8  vss  10000meg
XMN4_r_27_8  vw_route_27_8  we_route  iwrite_route_27_8  vss  sky130_fd_pr__nfet_01v8  w=0.5  l=0.5
X_rhebb_27_8  iwrite_route_27_8  inp_upper_8  ierr_dig_27  vcm_route  vdd vss  hebbian_mult
XMPRED_r_27_9  i_pred_27  vw_route_27_9  vss  vss  sky130_fd_pr__nfet_01v8  w=4  l=0.35
Cw_route_27_9  vw_route_27_9  vss  200f
R_bleed_27_9  vw_route_27_9  vss  10000meg
XMN4_r_27_9  vw_route_27_9  we_route  iwrite_route_27_9  vss  sky130_fd_pr__nfet_01v8  w=0.5  l=0.5
X_rhebb_27_9  iwrite_route_27_9  inp_upper_9  ierr_dig_27  vcm_route  vdd vss  hebbian_mult
XMPRED_r_27_10  i_pred_27  vw_route_27_10  vss  vss  sky130_fd_pr__nfet_01v8  w=4  l=0.35
Cw_route_27_10  vw_route_27_10  vss  200f
R_bleed_27_10  vw_route_27_10  vss  10000meg
XMN4_r_27_10  vw_route_27_10  we_route  iwrite_route_27_10  vss  sky130_fd_pr__nfet_01v8  w=0.5  l=0.5
X_rhebb_27_10  iwrite_route_27_10  inp_upper_10  ierr_dig_27  vcm_route  vdd vss  hebbian_mult
XMPRED_r_27_11  i_pred_27  vw_route_27_11  vss  vss  sky130_fd_pr__nfet_01v8  w=4  l=0.35
Cw_route_27_11  vw_route_27_11  vss  200f
R_bleed_27_11  vw_route_27_11  vss  10000meg
XMN4_r_27_11  vw_route_27_11  we_route  iwrite_route_27_11  vss  sky130_fd_pr__nfet_01v8  w=0.5  l=0.5
X_rhebb_27_11  iwrite_route_27_11  inp_upper_11  ierr_dig_27  vcm_route  vdd vss  hebbian_mult
XMPRED_r_27_12  i_pred_27  vw_route_27_12  vss  vss  sky130_fd_pr__nfet_01v8  w=4  l=0.35
Cw_route_27_12  vw_route_27_12  vss  200f
R_bleed_27_12  vw_route_27_12  vss  10000meg
XMN4_r_27_12  vw_route_27_12  we_route  iwrite_route_27_12  vss  sky130_fd_pr__nfet_01v8  w=0.5  l=0.5
X_rhebb_27_12  iwrite_route_27_12  inp_upper_12  ierr_dig_27  vcm_route  vdd vss  hebbian_mult
XMPRED_r_27_13  i_pred_27  vw_route_27_13  vss  vss  sky130_fd_pr__nfet_01v8  w=4  l=0.35
Cw_route_27_13  vw_route_27_13  vss  200f
R_bleed_27_13  vw_route_27_13  vss  10000meg
XMN4_r_27_13  vw_route_27_13  we_route  iwrite_route_27_13  vss  sky130_fd_pr__nfet_01v8  w=0.5  l=0.5
X_rhebb_27_13  iwrite_route_27_13  inp_upper_13  ierr_dig_27  vcm_route  vdd vss  hebbian_mult
XMPRED_r_27_14  i_pred_27  vw_route_27_14  vss  vss  sky130_fd_pr__nfet_01v8  w=4  l=0.35
Cw_route_27_14  vw_route_27_14  vss  200f
R_bleed_27_14  vw_route_27_14  vss  10000meg
XMN4_r_27_14  vw_route_27_14  we_route  iwrite_route_27_14  vss  sky130_fd_pr__nfet_01v8  w=0.5  l=0.5
X_rhebb_27_14  iwrite_route_27_14  inp_upper_14  ierr_dig_27  vcm_route  vdd vss  hebbian_mult
XMPRED_r_27_15  i_pred_27  vw_route_27_15  vss  vss  sky130_fd_pr__nfet_01v8  w=4  l=0.35
Cw_route_27_15  vw_route_27_15  vss  200f
R_bleed_27_15  vw_route_27_15  vss  10000meg
XMN4_r_27_15  vw_route_27_15  we_route  iwrite_route_27_15  vss  sky130_fd_pr__nfet_01v8  w=0.5  l=0.5
X_rhebb_27_15  iwrite_route_27_15  inp_upper_15  ierr_dig_27  vcm_route  vdd vss  hebbian_mult
XMPRED_r_27_16  i_pred_27  vw_route_27_16  vss  vss  sky130_fd_pr__nfet_01v8  w=4  l=0.35
Cw_route_27_16  vw_route_27_16  vss  200f
R_bleed_27_16  vw_route_27_16  vss  10000meg
XMN4_r_27_16  vw_route_27_16  we_route  iwrite_route_27_16  vss  sky130_fd_pr__nfet_01v8  w=0.5  l=0.5
X_rhebb_27_16  iwrite_route_27_16  inp_upper_16  ierr_dig_27  vcm_route  vdd vss  hebbian_mult
XMPRED_r_27_17  i_pred_27  vw_route_27_17  vss  vss  sky130_fd_pr__nfet_01v8  w=4  l=0.35
Cw_route_27_17  vw_route_27_17  vss  200f
R_bleed_27_17  vw_route_27_17  vss  10000meg
XMN4_r_27_17  vw_route_27_17  we_route  iwrite_route_27_17  vss  sky130_fd_pr__nfet_01v8  w=0.5  l=0.5
X_rhebb_27_17  iwrite_route_27_17  inp_upper_17  ierr_dig_27  vcm_route  vdd vss  hebbian_mult
XMPRED_r_27_18  i_pred_27  vw_route_27_18  vss  vss  sky130_fd_pr__nfet_01v8  w=4  l=0.35
Cw_route_27_18  vw_route_27_18  vss  200f
R_bleed_27_18  vw_route_27_18  vss  10000meg
XMN4_r_27_18  vw_route_27_18  we_route  iwrite_route_27_18  vss  sky130_fd_pr__nfet_01v8  w=0.5  l=0.5
X_rhebb_27_18  iwrite_route_27_18  inp_upper_18  ierr_dig_27  vcm_route  vdd vss  hebbian_mult
XMPRED_r_27_19  i_pred_27  vw_route_27_19  vss  vss  sky130_fd_pr__nfet_01v8  w=4  l=0.35
Cw_route_27_19  vw_route_27_19  vss  200f
R_bleed_27_19  vw_route_27_19  vss  10000meg
XMN4_r_27_19  vw_route_27_19  we_route  iwrite_route_27_19  vss  sky130_fd_pr__nfet_01v8  w=0.5  l=0.5
X_rhebb_27_19  iwrite_route_27_19  inp_upper_19  ierr_dig_27  vcm_route  vdd vss  hebbian_mult
XMPRED_r_27_20  i_pred_27  vw_route_27_20  vss  vss  sky130_fd_pr__nfet_01v8  w=4  l=0.35
Cw_route_27_20  vw_route_27_20  vss  200f
R_bleed_27_20  vw_route_27_20  vss  10000meg
XMN4_r_27_20  vw_route_27_20  we_route  iwrite_route_27_20  vss  sky130_fd_pr__nfet_01v8  w=0.5  l=0.5
X_rhebb_27_20  iwrite_route_27_20  inp_upper_20  ierr_dig_27  vcm_route  vdd vss  hebbian_mult
XMPRED_r_27_21  i_pred_27  vw_route_27_21  vss  vss  sky130_fd_pr__nfet_01v8  w=4  l=0.35
Cw_route_27_21  vw_route_27_21  vss  200f
R_bleed_27_21  vw_route_27_21  vss  10000meg
XMN4_r_27_21  vw_route_27_21  we_route  iwrite_route_27_21  vss  sky130_fd_pr__nfet_01v8  w=0.5  l=0.5
X_rhebb_27_21  iwrite_route_27_21  inp_upper_21  ierr_dig_27  vcm_route  vdd vss  hebbian_mult
XMPRED_r_27_22  i_pred_27  vw_route_27_22  vss  vss  sky130_fd_pr__nfet_01v8  w=4  l=0.35
Cw_route_27_22  vw_route_27_22  vss  200f
R_bleed_27_22  vw_route_27_22  vss  10000meg
XMN4_r_27_22  vw_route_27_22  we_route  iwrite_route_27_22  vss  sky130_fd_pr__nfet_01v8  w=0.5  l=0.5
X_rhebb_27_22  iwrite_route_27_22  inp_upper_22  ierr_dig_27  vcm_route  vdd vss  hebbian_mult
XMPRED_r_27_23  i_pred_27  vw_route_27_23  vss  vss  sky130_fd_pr__nfet_01v8  w=4  l=0.35
Cw_route_27_23  vw_route_27_23  vss  200f
R_bleed_27_23  vw_route_27_23  vss  10000meg
XMN4_r_27_23  vw_route_27_23  we_route  iwrite_route_27_23  vss  sky130_fd_pr__nfet_01v8  w=0.5  l=0.5
X_rhebb_27_23  iwrite_route_27_23  inp_upper_23  ierr_dig_27  vcm_route  vdd vss  hebbian_mult
XMPRED_r_27_24  i_pred_27  vw_route_27_24  vss  vss  sky130_fd_pr__nfet_01v8  w=4  l=0.35
Cw_route_27_24  vw_route_27_24  vss  200f
R_bleed_27_24  vw_route_27_24  vss  10000meg
XMN4_r_27_24  vw_route_27_24  we_route  iwrite_route_27_24  vss  sky130_fd_pr__nfet_01v8  w=0.5  l=0.5
X_rhebb_27_24  iwrite_route_27_24  inp_upper_24  ierr_dig_27  vcm_route  vdd vss  hebbian_mult
XMPRED_r_27_25  i_pred_27  vw_route_27_25  vss  vss  sky130_fd_pr__nfet_01v8  w=4  l=0.35
Cw_route_27_25  vw_route_27_25  vss  200f
R_bleed_27_25  vw_route_27_25  vss  10000meg
XMN4_r_27_25  vw_route_27_25  we_route  iwrite_route_27_25  vss  sky130_fd_pr__nfet_01v8  w=0.5  l=0.5
X_rhebb_27_25  iwrite_route_27_25  inp_upper_25  ierr_dig_27  vcm_route  vdd vss  hebbian_mult
XMPRED_r_27_26  i_pred_27  vw_route_27_26  vss  vss  sky130_fd_pr__nfet_01v8  w=4  l=0.35
Cw_route_27_26  vw_route_27_26  vss  200f
R_bleed_27_26  vw_route_27_26  vss  10000meg
XMN4_r_27_26  vw_route_27_26  we_route  iwrite_route_27_26  vss  sky130_fd_pr__nfet_01v8  w=0.5  l=0.5
X_rhebb_27_26  iwrite_route_27_26  inp_upper_26  ierr_dig_27  vcm_route  vdd vss  hebbian_mult
XMPRED_r_27_27  i_pred_27  vw_route_27_27  vss  vss  sky130_fd_pr__nfet_01v8  w=4  l=0.35
Cw_route_27_27  vw_route_27_27  vss  200f
R_bleed_27_27  vw_route_27_27  vss  10000meg
XMN4_r_27_27  vw_route_27_27  we_route  iwrite_route_27_27  vss  sky130_fd_pr__nfet_01v8  w=0.5  l=0.5
X_rhebb_27_27  iwrite_route_27_27  inp_upper_27  ierr_dig_27  vcm_route  vdd vss  hebbian_mult
XMPRED_r_27_28  i_pred_27  vw_route_27_28  vss  vss  sky130_fd_pr__nfet_01v8  w=4  l=0.35
Cw_route_27_28  vw_route_27_28  vss  200f
R_bleed_27_28  vw_route_27_28  vss  10000meg
XMN4_r_27_28  vw_route_27_28  we_route  iwrite_route_27_28  vss  sky130_fd_pr__nfet_01v8  w=0.5  l=0.5
X_rhebb_27_28  iwrite_route_27_28  inp_upper_28  ierr_dig_27  vcm_route  vdd vss  hebbian_mult
XMPRED_r_27_29  i_pred_27  vw_route_27_29  vss  vss  sky130_fd_pr__nfet_01v8  w=4  l=0.35
Cw_route_27_29  vw_route_27_29  vss  200f
R_bleed_27_29  vw_route_27_29  vss  10000meg
XMN4_r_27_29  vw_route_27_29  we_route  iwrite_route_27_29  vss  sky130_fd_pr__nfet_01v8  w=0.5  l=0.5
X_rhebb_27_29  iwrite_route_27_29  inp_upper_29  ierr_dig_27  vcm_route  vdd vss  hebbian_mult
XMPRED_r_27_30  i_pred_27  vw_route_27_30  vss  vss  sky130_fd_pr__nfet_01v8  w=4  l=0.35
Cw_route_27_30  vw_route_27_30  vss  200f
R_bleed_27_30  vw_route_27_30  vss  10000meg
XMN4_r_27_30  vw_route_27_30  we_route  iwrite_route_27_30  vss  sky130_fd_pr__nfet_01v8  w=0.5  l=0.5
X_rhebb_27_30  iwrite_route_27_30  inp_upper_30  ierr_dig_27  vcm_route  vdd vss  hebbian_mult
XMPRED_r_27_31  i_pred_27  vw_route_27_31  vss  vss  sky130_fd_pr__nfet_01v8  w=4  l=0.35
Cw_route_27_31  vw_route_27_31  vss  200f
R_bleed_27_31  vw_route_27_31  vss  10000meg
XMN4_r_27_31  vw_route_27_31  we_route  iwrite_route_27_31  vss  sky130_fd_pr__nfet_01v8  w=0.5  l=0.5
X_rhebb_27_31  iwrite_route_27_31  inp_upper_31  ierr_dig_27  vcm_route  vdd vss  hebbian_mult

* ── Destination row 28 ── 32 source connections ──────────────────────────
XMPRED_r_28_0  i_pred_28  vw_route_28_0  vss  vss  sky130_fd_pr__nfet_01v8  w=4  l=0.35
Cw_route_28_0  vw_route_28_0  vss  200f
R_bleed_28_0  vw_route_28_0  vss  10000meg
XMN4_r_28_0  vw_route_28_0  we_route  iwrite_route_28_0  vss  sky130_fd_pr__nfet_01v8  w=0.5  l=0.5
X_rhebb_28_0  iwrite_route_28_0  inp_upper_0  ierr_dig_28  vcm_route  vdd vss  hebbian_mult
XMPRED_r_28_1  i_pred_28  vw_route_28_1  vss  vss  sky130_fd_pr__nfet_01v8  w=4  l=0.35
Cw_route_28_1  vw_route_28_1  vss  200f
R_bleed_28_1  vw_route_28_1  vss  10000meg
XMN4_r_28_1  vw_route_28_1  we_route  iwrite_route_28_1  vss  sky130_fd_pr__nfet_01v8  w=0.5  l=0.5
X_rhebb_28_1  iwrite_route_28_1  inp_upper_1  ierr_dig_28  vcm_route  vdd vss  hebbian_mult
XMPRED_r_28_2  i_pred_28  vw_route_28_2  vss  vss  sky130_fd_pr__nfet_01v8  w=4  l=0.35
Cw_route_28_2  vw_route_28_2  vss  200f
R_bleed_28_2  vw_route_28_2  vss  10000meg
XMN4_r_28_2  vw_route_28_2  we_route  iwrite_route_28_2  vss  sky130_fd_pr__nfet_01v8  w=0.5  l=0.5
X_rhebb_28_2  iwrite_route_28_2  inp_upper_2  ierr_dig_28  vcm_route  vdd vss  hebbian_mult
XMPRED_r_28_3  i_pred_28  vw_route_28_3  vss  vss  sky130_fd_pr__nfet_01v8  w=4  l=0.35
Cw_route_28_3  vw_route_28_3  vss  200f
R_bleed_28_3  vw_route_28_3  vss  10000meg
XMN4_r_28_3  vw_route_28_3  we_route  iwrite_route_28_3  vss  sky130_fd_pr__nfet_01v8  w=0.5  l=0.5
X_rhebb_28_3  iwrite_route_28_3  inp_upper_3  ierr_dig_28  vcm_route  vdd vss  hebbian_mult
XMPRED_r_28_4  i_pred_28  vw_route_28_4  vss  vss  sky130_fd_pr__nfet_01v8  w=4  l=0.35
Cw_route_28_4  vw_route_28_4  vss  200f
R_bleed_28_4  vw_route_28_4  vss  10000meg
XMN4_r_28_4  vw_route_28_4  we_route  iwrite_route_28_4  vss  sky130_fd_pr__nfet_01v8  w=0.5  l=0.5
X_rhebb_28_4  iwrite_route_28_4  inp_upper_4  ierr_dig_28  vcm_route  vdd vss  hebbian_mult
XMPRED_r_28_5  i_pred_28  vw_route_28_5  vss  vss  sky130_fd_pr__nfet_01v8  w=4  l=0.35
Cw_route_28_5  vw_route_28_5  vss  200f
R_bleed_28_5  vw_route_28_5  vss  10000meg
XMN4_r_28_5  vw_route_28_5  we_route  iwrite_route_28_5  vss  sky130_fd_pr__nfet_01v8  w=0.5  l=0.5
X_rhebb_28_5  iwrite_route_28_5  inp_upper_5  ierr_dig_28  vcm_route  vdd vss  hebbian_mult
XMPRED_r_28_6  i_pred_28  vw_route_28_6  vss  vss  sky130_fd_pr__nfet_01v8  w=4  l=0.35
Cw_route_28_6  vw_route_28_6  vss  200f
R_bleed_28_6  vw_route_28_6  vss  10000meg
XMN4_r_28_6  vw_route_28_6  we_route  iwrite_route_28_6  vss  sky130_fd_pr__nfet_01v8  w=0.5  l=0.5
X_rhebb_28_6  iwrite_route_28_6  inp_upper_6  ierr_dig_28  vcm_route  vdd vss  hebbian_mult
XMPRED_r_28_7  i_pred_28  vw_route_28_7  vss  vss  sky130_fd_pr__nfet_01v8  w=4  l=0.35
Cw_route_28_7  vw_route_28_7  vss  200f
R_bleed_28_7  vw_route_28_7  vss  10000meg
XMN4_r_28_7  vw_route_28_7  we_route  iwrite_route_28_7  vss  sky130_fd_pr__nfet_01v8  w=0.5  l=0.5
X_rhebb_28_7  iwrite_route_28_7  inp_upper_7  ierr_dig_28  vcm_route  vdd vss  hebbian_mult
XMPRED_r_28_8  i_pred_28  vw_route_28_8  vss  vss  sky130_fd_pr__nfet_01v8  w=4  l=0.35
Cw_route_28_8  vw_route_28_8  vss  200f
R_bleed_28_8  vw_route_28_8  vss  10000meg
XMN4_r_28_8  vw_route_28_8  we_route  iwrite_route_28_8  vss  sky130_fd_pr__nfet_01v8  w=0.5  l=0.5
X_rhebb_28_8  iwrite_route_28_8  inp_upper_8  ierr_dig_28  vcm_route  vdd vss  hebbian_mult
XMPRED_r_28_9  i_pred_28  vw_route_28_9  vss  vss  sky130_fd_pr__nfet_01v8  w=4  l=0.35
Cw_route_28_9  vw_route_28_9  vss  200f
R_bleed_28_9  vw_route_28_9  vss  10000meg
XMN4_r_28_9  vw_route_28_9  we_route  iwrite_route_28_9  vss  sky130_fd_pr__nfet_01v8  w=0.5  l=0.5
X_rhebb_28_9  iwrite_route_28_9  inp_upper_9  ierr_dig_28  vcm_route  vdd vss  hebbian_mult
XMPRED_r_28_10  i_pred_28  vw_route_28_10  vss  vss  sky130_fd_pr__nfet_01v8  w=4  l=0.35
Cw_route_28_10  vw_route_28_10  vss  200f
R_bleed_28_10  vw_route_28_10  vss  10000meg
XMN4_r_28_10  vw_route_28_10  we_route  iwrite_route_28_10  vss  sky130_fd_pr__nfet_01v8  w=0.5  l=0.5
X_rhebb_28_10  iwrite_route_28_10  inp_upper_10  ierr_dig_28  vcm_route  vdd vss  hebbian_mult
XMPRED_r_28_11  i_pred_28  vw_route_28_11  vss  vss  sky130_fd_pr__nfet_01v8  w=4  l=0.35
Cw_route_28_11  vw_route_28_11  vss  200f
R_bleed_28_11  vw_route_28_11  vss  10000meg
XMN4_r_28_11  vw_route_28_11  we_route  iwrite_route_28_11  vss  sky130_fd_pr__nfet_01v8  w=0.5  l=0.5
X_rhebb_28_11  iwrite_route_28_11  inp_upper_11  ierr_dig_28  vcm_route  vdd vss  hebbian_mult
XMPRED_r_28_12  i_pred_28  vw_route_28_12  vss  vss  sky130_fd_pr__nfet_01v8  w=4  l=0.35
Cw_route_28_12  vw_route_28_12  vss  200f
R_bleed_28_12  vw_route_28_12  vss  10000meg
XMN4_r_28_12  vw_route_28_12  we_route  iwrite_route_28_12  vss  sky130_fd_pr__nfet_01v8  w=0.5  l=0.5
X_rhebb_28_12  iwrite_route_28_12  inp_upper_12  ierr_dig_28  vcm_route  vdd vss  hebbian_mult
XMPRED_r_28_13  i_pred_28  vw_route_28_13  vss  vss  sky130_fd_pr__nfet_01v8  w=4  l=0.35
Cw_route_28_13  vw_route_28_13  vss  200f
R_bleed_28_13  vw_route_28_13  vss  10000meg
XMN4_r_28_13  vw_route_28_13  we_route  iwrite_route_28_13  vss  sky130_fd_pr__nfet_01v8  w=0.5  l=0.5
X_rhebb_28_13  iwrite_route_28_13  inp_upper_13  ierr_dig_28  vcm_route  vdd vss  hebbian_mult
XMPRED_r_28_14  i_pred_28  vw_route_28_14  vss  vss  sky130_fd_pr__nfet_01v8  w=4  l=0.35
Cw_route_28_14  vw_route_28_14  vss  200f
R_bleed_28_14  vw_route_28_14  vss  10000meg
XMN4_r_28_14  vw_route_28_14  we_route  iwrite_route_28_14  vss  sky130_fd_pr__nfet_01v8  w=0.5  l=0.5
X_rhebb_28_14  iwrite_route_28_14  inp_upper_14  ierr_dig_28  vcm_route  vdd vss  hebbian_mult
XMPRED_r_28_15  i_pred_28  vw_route_28_15  vss  vss  sky130_fd_pr__nfet_01v8  w=4  l=0.35
Cw_route_28_15  vw_route_28_15  vss  200f
R_bleed_28_15  vw_route_28_15  vss  10000meg
XMN4_r_28_15  vw_route_28_15  we_route  iwrite_route_28_15  vss  sky130_fd_pr__nfet_01v8  w=0.5  l=0.5
X_rhebb_28_15  iwrite_route_28_15  inp_upper_15  ierr_dig_28  vcm_route  vdd vss  hebbian_mult
XMPRED_r_28_16  i_pred_28  vw_route_28_16  vss  vss  sky130_fd_pr__nfet_01v8  w=4  l=0.35
Cw_route_28_16  vw_route_28_16  vss  200f
R_bleed_28_16  vw_route_28_16  vss  10000meg
XMN4_r_28_16  vw_route_28_16  we_route  iwrite_route_28_16  vss  sky130_fd_pr__nfet_01v8  w=0.5  l=0.5
X_rhebb_28_16  iwrite_route_28_16  inp_upper_16  ierr_dig_28  vcm_route  vdd vss  hebbian_mult
XMPRED_r_28_17  i_pred_28  vw_route_28_17  vss  vss  sky130_fd_pr__nfet_01v8  w=4  l=0.35
Cw_route_28_17  vw_route_28_17  vss  200f
R_bleed_28_17  vw_route_28_17  vss  10000meg
XMN4_r_28_17  vw_route_28_17  we_route  iwrite_route_28_17  vss  sky130_fd_pr__nfet_01v8  w=0.5  l=0.5
X_rhebb_28_17  iwrite_route_28_17  inp_upper_17  ierr_dig_28  vcm_route  vdd vss  hebbian_mult
XMPRED_r_28_18  i_pred_28  vw_route_28_18  vss  vss  sky130_fd_pr__nfet_01v8  w=4  l=0.35
Cw_route_28_18  vw_route_28_18  vss  200f
R_bleed_28_18  vw_route_28_18  vss  10000meg
XMN4_r_28_18  vw_route_28_18  we_route  iwrite_route_28_18  vss  sky130_fd_pr__nfet_01v8  w=0.5  l=0.5
X_rhebb_28_18  iwrite_route_28_18  inp_upper_18  ierr_dig_28  vcm_route  vdd vss  hebbian_mult
XMPRED_r_28_19  i_pred_28  vw_route_28_19  vss  vss  sky130_fd_pr__nfet_01v8  w=4  l=0.35
Cw_route_28_19  vw_route_28_19  vss  200f
R_bleed_28_19  vw_route_28_19  vss  10000meg
XMN4_r_28_19  vw_route_28_19  we_route  iwrite_route_28_19  vss  sky130_fd_pr__nfet_01v8  w=0.5  l=0.5
X_rhebb_28_19  iwrite_route_28_19  inp_upper_19  ierr_dig_28  vcm_route  vdd vss  hebbian_mult
XMPRED_r_28_20  i_pred_28  vw_route_28_20  vss  vss  sky130_fd_pr__nfet_01v8  w=4  l=0.35
Cw_route_28_20  vw_route_28_20  vss  200f
R_bleed_28_20  vw_route_28_20  vss  10000meg
XMN4_r_28_20  vw_route_28_20  we_route  iwrite_route_28_20  vss  sky130_fd_pr__nfet_01v8  w=0.5  l=0.5
X_rhebb_28_20  iwrite_route_28_20  inp_upper_20  ierr_dig_28  vcm_route  vdd vss  hebbian_mult
XMPRED_r_28_21  i_pred_28  vw_route_28_21  vss  vss  sky130_fd_pr__nfet_01v8  w=4  l=0.35
Cw_route_28_21  vw_route_28_21  vss  200f
R_bleed_28_21  vw_route_28_21  vss  10000meg
XMN4_r_28_21  vw_route_28_21  we_route  iwrite_route_28_21  vss  sky130_fd_pr__nfet_01v8  w=0.5  l=0.5
X_rhebb_28_21  iwrite_route_28_21  inp_upper_21  ierr_dig_28  vcm_route  vdd vss  hebbian_mult
XMPRED_r_28_22  i_pred_28  vw_route_28_22  vss  vss  sky130_fd_pr__nfet_01v8  w=4  l=0.35
Cw_route_28_22  vw_route_28_22  vss  200f
R_bleed_28_22  vw_route_28_22  vss  10000meg
XMN4_r_28_22  vw_route_28_22  we_route  iwrite_route_28_22  vss  sky130_fd_pr__nfet_01v8  w=0.5  l=0.5
X_rhebb_28_22  iwrite_route_28_22  inp_upper_22  ierr_dig_28  vcm_route  vdd vss  hebbian_mult
XMPRED_r_28_23  i_pred_28  vw_route_28_23  vss  vss  sky130_fd_pr__nfet_01v8  w=4  l=0.35
Cw_route_28_23  vw_route_28_23  vss  200f
R_bleed_28_23  vw_route_28_23  vss  10000meg
XMN4_r_28_23  vw_route_28_23  we_route  iwrite_route_28_23  vss  sky130_fd_pr__nfet_01v8  w=0.5  l=0.5
X_rhebb_28_23  iwrite_route_28_23  inp_upper_23  ierr_dig_28  vcm_route  vdd vss  hebbian_mult
XMPRED_r_28_24  i_pred_28  vw_route_28_24  vss  vss  sky130_fd_pr__nfet_01v8  w=4  l=0.35
Cw_route_28_24  vw_route_28_24  vss  200f
R_bleed_28_24  vw_route_28_24  vss  10000meg
XMN4_r_28_24  vw_route_28_24  we_route  iwrite_route_28_24  vss  sky130_fd_pr__nfet_01v8  w=0.5  l=0.5
X_rhebb_28_24  iwrite_route_28_24  inp_upper_24  ierr_dig_28  vcm_route  vdd vss  hebbian_mult
XMPRED_r_28_25  i_pred_28  vw_route_28_25  vss  vss  sky130_fd_pr__nfet_01v8  w=4  l=0.35
Cw_route_28_25  vw_route_28_25  vss  200f
R_bleed_28_25  vw_route_28_25  vss  10000meg
XMN4_r_28_25  vw_route_28_25  we_route  iwrite_route_28_25  vss  sky130_fd_pr__nfet_01v8  w=0.5  l=0.5
X_rhebb_28_25  iwrite_route_28_25  inp_upper_25  ierr_dig_28  vcm_route  vdd vss  hebbian_mult
XMPRED_r_28_26  i_pred_28  vw_route_28_26  vss  vss  sky130_fd_pr__nfet_01v8  w=4  l=0.35
Cw_route_28_26  vw_route_28_26  vss  200f
R_bleed_28_26  vw_route_28_26  vss  10000meg
XMN4_r_28_26  vw_route_28_26  we_route  iwrite_route_28_26  vss  sky130_fd_pr__nfet_01v8  w=0.5  l=0.5
X_rhebb_28_26  iwrite_route_28_26  inp_upper_26  ierr_dig_28  vcm_route  vdd vss  hebbian_mult
XMPRED_r_28_27  i_pred_28  vw_route_28_27  vss  vss  sky130_fd_pr__nfet_01v8  w=4  l=0.35
Cw_route_28_27  vw_route_28_27  vss  200f
R_bleed_28_27  vw_route_28_27  vss  10000meg
XMN4_r_28_27  vw_route_28_27  we_route  iwrite_route_28_27  vss  sky130_fd_pr__nfet_01v8  w=0.5  l=0.5
X_rhebb_28_27  iwrite_route_28_27  inp_upper_27  ierr_dig_28  vcm_route  vdd vss  hebbian_mult
XMPRED_r_28_28  i_pred_28  vw_route_28_28  vss  vss  sky130_fd_pr__nfet_01v8  w=4  l=0.35
Cw_route_28_28  vw_route_28_28  vss  200f
R_bleed_28_28  vw_route_28_28  vss  10000meg
XMN4_r_28_28  vw_route_28_28  we_route  iwrite_route_28_28  vss  sky130_fd_pr__nfet_01v8  w=0.5  l=0.5
X_rhebb_28_28  iwrite_route_28_28  inp_upper_28  ierr_dig_28  vcm_route  vdd vss  hebbian_mult
XMPRED_r_28_29  i_pred_28  vw_route_28_29  vss  vss  sky130_fd_pr__nfet_01v8  w=4  l=0.35
Cw_route_28_29  vw_route_28_29  vss  200f
R_bleed_28_29  vw_route_28_29  vss  10000meg
XMN4_r_28_29  vw_route_28_29  we_route  iwrite_route_28_29  vss  sky130_fd_pr__nfet_01v8  w=0.5  l=0.5
X_rhebb_28_29  iwrite_route_28_29  inp_upper_29  ierr_dig_28  vcm_route  vdd vss  hebbian_mult
XMPRED_r_28_30  i_pred_28  vw_route_28_30  vss  vss  sky130_fd_pr__nfet_01v8  w=4  l=0.35
Cw_route_28_30  vw_route_28_30  vss  200f
R_bleed_28_30  vw_route_28_30  vss  10000meg
XMN4_r_28_30  vw_route_28_30  we_route  iwrite_route_28_30  vss  sky130_fd_pr__nfet_01v8  w=0.5  l=0.5
X_rhebb_28_30  iwrite_route_28_30  inp_upper_30  ierr_dig_28  vcm_route  vdd vss  hebbian_mult
XMPRED_r_28_31  i_pred_28  vw_route_28_31  vss  vss  sky130_fd_pr__nfet_01v8  w=4  l=0.35
Cw_route_28_31  vw_route_28_31  vss  200f
R_bleed_28_31  vw_route_28_31  vss  10000meg
XMN4_r_28_31  vw_route_28_31  we_route  iwrite_route_28_31  vss  sky130_fd_pr__nfet_01v8  w=0.5  l=0.5
X_rhebb_28_31  iwrite_route_28_31  inp_upper_31  ierr_dig_28  vcm_route  vdd vss  hebbian_mult

* ── Destination row 29 ── 32 source connections ──────────────────────────
XMPRED_r_29_0  i_pred_29  vw_route_29_0  vss  vss  sky130_fd_pr__nfet_01v8  w=4  l=0.35
Cw_route_29_0  vw_route_29_0  vss  200f
R_bleed_29_0  vw_route_29_0  vss  10000meg
XMN4_r_29_0  vw_route_29_0  we_route  iwrite_route_29_0  vss  sky130_fd_pr__nfet_01v8  w=0.5  l=0.5
X_rhebb_29_0  iwrite_route_29_0  inp_upper_0  ierr_dig_29  vcm_route  vdd vss  hebbian_mult
XMPRED_r_29_1  i_pred_29  vw_route_29_1  vss  vss  sky130_fd_pr__nfet_01v8  w=4  l=0.35
Cw_route_29_1  vw_route_29_1  vss  200f
R_bleed_29_1  vw_route_29_1  vss  10000meg
XMN4_r_29_1  vw_route_29_1  we_route  iwrite_route_29_1  vss  sky130_fd_pr__nfet_01v8  w=0.5  l=0.5
X_rhebb_29_1  iwrite_route_29_1  inp_upper_1  ierr_dig_29  vcm_route  vdd vss  hebbian_mult
XMPRED_r_29_2  i_pred_29  vw_route_29_2  vss  vss  sky130_fd_pr__nfet_01v8  w=4  l=0.35
Cw_route_29_2  vw_route_29_2  vss  200f
R_bleed_29_2  vw_route_29_2  vss  10000meg
XMN4_r_29_2  vw_route_29_2  we_route  iwrite_route_29_2  vss  sky130_fd_pr__nfet_01v8  w=0.5  l=0.5
X_rhebb_29_2  iwrite_route_29_2  inp_upper_2  ierr_dig_29  vcm_route  vdd vss  hebbian_mult
XMPRED_r_29_3  i_pred_29  vw_route_29_3  vss  vss  sky130_fd_pr__nfet_01v8  w=4  l=0.35
Cw_route_29_3  vw_route_29_3  vss  200f
R_bleed_29_3  vw_route_29_3  vss  10000meg
XMN4_r_29_3  vw_route_29_3  we_route  iwrite_route_29_3  vss  sky130_fd_pr__nfet_01v8  w=0.5  l=0.5
X_rhebb_29_3  iwrite_route_29_3  inp_upper_3  ierr_dig_29  vcm_route  vdd vss  hebbian_mult
XMPRED_r_29_4  i_pred_29  vw_route_29_4  vss  vss  sky130_fd_pr__nfet_01v8  w=4  l=0.35
Cw_route_29_4  vw_route_29_4  vss  200f
R_bleed_29_4  vw_route_29_4  vss  10000meg
XMN4_r_29_4  vw_route_29_4  we_route  iwrite_route_29_4  vss  sky130_fd_pr__nfet_01v8  w=0.5  l=0.5
X_rhebb_29_4  iwrite_route_29_4  inp_upper_4  ierr_dig_29  vcm_route  vdd vss  hebbian_mult
XMPRED_r_29_5  i_pred_29  vw_route_29_5  vss  vss  sky130_fd_pr__nfet_01v8  w=4  l=0.35
Cw_route_29_5  vw_route_29_5  vss  200f
R_bleed_29_5  vw_route_29_5  vss  10000meg
XMN4_r_29_5  vw_route_29_5  we_route  iwrite_route_29_5  vss  sky130_fd_pr__nfet_01v8  w=0.5  l=0.5
X_rhebb_29_5  iwrite_route_29_5  inp_upper_5  ierr_dig_29  vcm_route  vdd vss  hebbian_mult
XMPRED_r_29_6  i_pred_29  vw_route_29_6  vss  vss  sky130_fd_pr__nfet_01v8  w=4  l=0.35
Cw_route_29_6  vw_route_29_6  vss  200f
R_bleed_29_6  vw_route_29_6  vss  10000meg
XMN4_r_29_6  vw_route_29_6  we_route  iwrite_route_29_6  vss  sky130_fd_pr__nfet_01v8  w=0.5  l=0.5
X_rhebb_29_6  iwrite_route_29_6  inp_upper_6  ierr_dig_29  vcm_route  vdd vss  hebbian_mult
XMPRED_r_29_7  i_pred_29  vw_route_29_7  vss  vss  sky130_fd_pr__nfet_01v8  w=4  l=0.35
Cw_route_29_7  vw_route_29_7  vss  200f
R_bleed_29_7  vw_route_29_7  vss  10000meg
XMN4_r_29_7  vw_route_29_7  we_route  iwrite_route_29_7  vss  sky130_fd_pr__nfet_01v8  w=0.5  l=0.5
X_rhebb_29_7  iwrite_route_29_7  inp_upper_7  ierr_dig_29  vcm_route  vdd vss  hebbian_mult
XMPRED_r_29_8  i_pred_29  vw_route_29_8  vss  vss  sky130_fd_pr__nfet_01v8  w=4  l=0.35
Cw_route_29_8  vw_route_29_8  vss  200f
R_bleed_29_8  vw_route_29_8  vss  10000meg
XMN4_r_29_8  vw_route_29_8  we_route  iwrite_route_29_8  vss  sky130_fd_pr__nfet_01v8  w=0.5  l=0.5
X_rhebb_29_8  iwrite_route_29_8  inp_upper_8  ierr_dig_29  vcm_route  vdd vss  hebbian_mult
XMPRED_r_29_9  i_pred_29  vw_route_29_9  vss  vss  sky130_fd_pr__nfet_01v8  w=4  l=0.35
Cw_route_29_9  vw_route_29_9  vss  200f
R_bleed_29_9  vw_route_29_9  vss  10000meg
XMN4_r_29_9  vw_route_29_9  we_route  iwrite_route_29_9  vss  sky130_fd_pr__nfet_01v8  w=0.5  l=0.5
X_rhebb_29_9  iwrite_route_29_9  inp_upper_9  ierr_dig_29  vcm_route  vdd vss  hebbian_mult
XMPRED_r_29_10  i_pred_29  vw_route_29_10  vss  vss  sky130_fd_pr__nfet_01v8  w=4  l=0.35
Cw_route_29_10  vw_route_29_10  vss  200f
R_bleed_29_10  vw_route_29_10  vss  10000meg
XMN4_r_29_10  vw_route_29_10  we_route  iwrite_route_29_10  vss  sky130_fd_pr__nfet_01v8  w=0.5  l=0.5
X_rhebb_29_10  iwrite_route_29_10  inp_upper_10  ierr_dig_29  vcm_route  vdd vss  hebbian_mult
XMPRED_r_29_11  i_pred_29  vw_route_29_11  vss  vss  sky130_fd_pr__nfet_01v8  w=4  l=0.35
Cw_route_29_11  vw_route_29_11  vss  200f
R_bleed_29_11  vw_route_29_11  vss  10000meg
XMN4_r_29_11  vw_route_29_11  we_route  iwrite_route_29_11  vss  sky130_fd_pr__nfet_01v8  w=0.5  l=0.5
X_rhebb_29_11  iwrite_route_29_11  inp_upper_11  ierr_dig_29  vcm_route  vdd vss  hebbian_mult
XMPRED_r_29_12  i_pred_29  vw_route_29_12  vss  vss  sky130_fd_pr__nfet_01v8  w=4  l=0.35
Cw_route_29_12  vw_route_29_12  vss  200f
R_bleed_29_12  vw_route_29_12  vss  10000meg
XMN4_r_29_12  vw_route_29_12  we_route  iwrite_route_29_12  vss  sky130_fd_pr__nfet_01v8  w=0.5  l=0.5
X_rhebb_29_12  iwrite_route_29_12  inp_upper_12  ierr_dig_29  vcm_route  vdd vss  hebbian_mult
XMPRED_r_29_13  i_pred_29  vw_route_29_13  vss  vss  sky130_fd_pr__nfet_01v8  w=4  l=0.35
Cw_route_29_13  vw_route_29_13  vss  200f
R_bleed_29_13  vw_route_29_13  vss  10000meg
XMN4_r_29_13  vw_route_29_13  we_route  iwrite_route_29_13  vss  sky130_fd_pr__nfet_01v8  w=0.5  l=0.5
X_rhebb_29_13  iwrite_route_29_13  inp_upper_13  ierr_dig_29  vcm_route  vdd vss  hebbian_mult
XMPRED_r_29_14  i_pred_29  vw_route_29_14  vss  vss  sky130_fd_pr__nfet_01v8  w=4  l=0.35
Cw_route_29_14  vw_route_29_14  vss  200f
R_bleed_29_14  vw_route_29_14  vss  10000meg
XMN4_r_29_14  vw_route_29_14  we_route  iwrite_route_29_14  vss  sky130_fd_pr__nfet_01v8  w=0.5  l=0.5
X_rhebb_29_14  iwrite_route_29_14  inp_upper_14  ierr_dig_29  vcm_route  vdd vss  hebbian_mult
XMPRED_r_29_15  i_pred_29  vw_route_29_15  vss  vss  sky130_fd_pr__nfet_01v8  w=4  l=0.35
Cw_route_29_15  vw_route_29_15  vss  200f
R_bleed_29_15  vw_route_29_15  vss  10000meg
XMN4_r_29_15  vw_route_29_15  we_route  iwrite_route_29_15  vss  sky130_fd_pr__nfet_01v8  w=0.5  l=0.5
X_rhebb_29_15  iwrite_route_29_15  inp_upper_15  ierr_dig_29  vcm_route  vdd vss  hebbian_mult
XMPRED_r_29_16  i_pred_29  vw_route_29_16  vss  vss  sky130_fd_pr__nfet_01v8  w=4  l=0.35
Cw_route_29_16  vw_route_29_16  vss  200f
R_bleed_29_16  vw_route_29_16  vss  10000meg
XMN4_r_29_16  vw_route_29_16  we_route  iwrite_route_29_16  vss  sky130_fd_pr__nfet_01v8  w=0.5  l=0.5
X_rhebb_29_16  iwrite_route_29_16  inp_upper_16  ierr_dig_29  vcm_route  vdd vss  hebbian_mult
XMPRED_r_29_17  i_pred_29  vw_route_29_17  vss  vss  sky130_fd_pr__nfet_01v8  w=4  l=0.35
Cw_route_29_17  vw_route_29_17  vss  200f
R_bleed_29_17  vw_route_29_17  vss  10000meg
XMN4_r_29_17  vw_route_29_17  we_route  iwrite_route_29_17  vss  sky130_fd_pr__nfet_01v8  w=0.5  l=0.5
X_rhebb_29_17  iwrite_route_29_17  inp_upper_17  ierr_dig_29  vcm_route  vdd vss  hebbian_mult
XMPRED_r_29_18  i_pred_29  vw_route_29_18  vss  vss  sky130_fd_pr__nfet_01v8  w=4  l=0.35
Cw_route_29_18  vw_route_29_18  vss  200f
R_bleed_29_18  vw_route_29_18  vss  10000meg
XMN4_r_29_18  vw_route_29_18  we_route  iwrite_route_29_18  vss  sky130_fd_pr__nfet_01v8  w=0.5  l=0.5
X_rhebb_29_18  iwrite_route_29_18  inp_upper_18  ierr_dig_29  vcm_route  vdd vss  hebbian_mult
XMPRED_r_29_19  i_pred_29  vw_route_29_19  vss  vss  sky130_fd_pr__nfet_01v8  w=4  l=0.35
Cw_route_29_19  vw_route_29_19  vss  200f
R_bleed_29_19  vw_route_29_19  vss  10000meg
XMN4_r_29_19  vw_route_29_19  we_route  iwrite_route_29_19  vss  sky130_fd_pr__nfet_01v8  w=0.5  l=0.5
X_rhebb_29_19  iwrite_route_29_19  inp_upper_19  ierr_dig_29  vcm_route  vdd vss  hebbian_mult
XMPRED_r_29_20  i_pred_29  vw_route_29_20  vss  vss  sky130_fd_pr__nfet_01v8  w=4  l=0.35
Cw_route_29_20  vw_route_29_20  vss  200f
R_bleed_29_20  vw_route_29_20  vss  10000meg
XMN4_r_29_20  vw_route_29_20  we_route  iwrite_route_29_20  vss  sky130_fd_pr__nfet_01v8  w=0.5  l=0.5
X_rhebb_29_20  iwrite_route_29_20  inp_upper_20  ierr_dig_29  vcm_route  vdd vss  hebbian_mult
XMPRED_r_29_21  i_pred_29  vw_route_29_21  vss  vss  sky130_fd_pr__nfet_01v8  w=4  l=0.35
Cw_route_29_21  vw_route_29_21  vss  200f
R_bleed_29_21  vw_route_29_21  vss  10000meg
XMN4_r_29_21  vw_route_29_21  we_route  iwrite_route_29_21  vss  sky130_fd_pr__nfet_01v8  w=0.5  l=0.5
X_rhebb_29_21  iwrite_route_29_21  inp_upper_21  ierr_dig_29  vcm_route  vdd vss  hebbian_mult
XMPRED_r_29_22  i_pred_29  vw_route_29_22  vss  vss  sky130_fd_pr__nfet_01v8  w=4  l=0.35
Cw_route_29_22  vw_route_29_22  vss  200f
R_bleed_29_22  vw_route_29_22  vss  10000meg
XMN4_r_29_22  vw_route_29_22  we_route  iwrite_route_29_22  vss  sky130_fd_pr__nfet_01v8  w=0.5  l=0.5
X_rhebb_29_22  iwrite_route_29_22  inp_upper_22  ierr_dig_29  vcm_route  vdd vss  hebbian_mult
XMPRED_r_29_23  i_pred_29  vw_route_29_23  vss  vss  sky130_fd_pr__nfet_01v8  w=4  l=0.35
Cw_route_29_23  vw_route_29_23  vss  200f
R_bleed_29_23  vw_route_29_23  vss  10000meg
XMN4_r_29_23  vw_route_29_23  we_route  iwrite_route_29_23  vss  sky130_fd_pr__nfet_01v8  w=0.5  l=0.5
X_rhebb_29_23  iwrite_route_29_23  inp_upper_23  ierr_dig_29  vcm_route  vdd vss  hebbian_mult
XMPRED_r_29_24  i_pred_29  vw_route_29_24  vss  vss  sky130_fd_pr__nfet_01v8  w=4  l=0.35
Cw_route_29_24  vw_route_29_24  vss  200f
R_bleed_29_24  vw_route_29_24  vss  10000meg
XMN4_r_29_24  vw_route_29_24  we_route  iwrite_route_29_24  vss  sky130_fd_pr__nfet_01v8  w=0.5  l=0.5
X_rhebb_29_24  iwrite_route_29_24  inp_upper_24  ierr_dig_29  vcm_route  vdd vss  hebbian_mult
XMPRED_r_29_25  i_pred_29  vw_route_29_25  vss  vss  sky130_fd_pr__nfet_01v8  w=4  l=0.35
Cw_route_29_25  vw_route_29_25  vss  200f
R_bleed_29_25  vw_route_29_25  vss  10000meg
XMN4_r_29_25  vw_route_29_25  we_route  iwrite_route_29_25  vss  sky130_fd_pr__nfet_01v8  w=0.5  l=0.5
X_rhebb_29_25  iwrite_route_29_25  inp_upper_25  ierr_dig_29  vcm_route  vdd vss  hebbian_mult
XMPRED_r_29_26  i_pred_29  vw_route_29_26  vss  vss  sky130_fd_pr__nfet_01v8  w=4  l=0.35
Cw_route_29_26  vw_route_29_26  vss  200f
R_bleed_29_26  vw_route_29_26  vss  10000meg
XMN4_r_29_26  vw_route_29_26  we_route  iwrite_route_29_26  vss  sky130_fd_pr__nfet_01v8  w=0.5  l=0.5
X_rhebb_29_26  iwrite_route_29_26  inp_upper_26  ierr_dig_29  vcm_route  vdd vss  hebbian_mult
XMPRED_r_29_27  i_pred_29  vw_route_29_27  vss  vss  sky130_fd_pr__nfet_01v8  w=4  l=0.35
Cw_route_29_27  vw_route_29_27  vss  200f
R_bleed_29_27  vw_route_29_27  vss  10000meg
XMN4_r_29_27  vw_route_29_27  we_route  iwrite_route_29_27  vss  sky130_fd_pr__nfet_01v8  w=0.5  l=0.5
X_rhebb_29_27  iwrite_route_29_27  inp_upper_27  ierr_dig_29  vcm_route  vdd vss  hebbian_mult
XMPRED_r_29_28  i_pred_29  vw_route_29_28  vss  vss  sky130_fd_pr__nfet_01v8  w=4  l=0.35
Cw_route_29_28  vw_route_29_28  vss  200f
R_bleed_29_28  vw_route_29_28  vss  10000meg
XMN4_r_29_28  vw_route_29_28  we_route  iwrite_route_29_28  vss  sky130_fd_pr__nfet_01v8  w=0.5  l=0.5
X_rhebb_29_28  iwrite_route_29_28  inp_upper_28  ierr_dig_29  vcm_route  vdd vss  hebbian_mult
XMPRED_r_29_29  i_pred_29  vw_route_29_29  vss  vss  sky130_fd_pr__nfet_01v8  w=4  l=0.35
Cw_route_29_29  vw_route_29_29  vss  200f
R_bleed_29_29  vw_route_29_29  vss  10000meg
XMN4_r_29_29  vw_route_29_29  we_route  iwrite_route_29_29  vss  sky130_fd_pr__nfet_01v8  w=0.5  l=0.5
X_rhebb_29_29  iwrite_route_29_29  inp_upper_29  ierr_dig_29  vcm_route  vdd vss  hebbian_mult
XMPRED_r_29_30  i_pred_29  vw_route_29_30  vss  vss  sky130_fd_pr__nfet_01v8  w=4  l=0.35
Cw_route_29_30  vw_route_29_30  vss  200f
R_bleed_29_30  vw_route_29_30  vss  10000meg
XMN4_r_29_30  vw_route_29_30  we_route  iwrite_route_29_30  vss  sky130_fd_pr__nfet_01v8  w=0.5  l=0.5
X_rhebb_29_30  iwrite_route_29_30  inp_upper_30  ierr_dig_29  vcm_route  vdd vss  hebbian_mult
XMPRED_r_29_31  i_pred_29  vw_route_29_31  vss  vss  sky130_fd_pr__nfet_01v8  w=4  l=0.35
Cw_route_29_31  vw_route_29_31  vss  200f
R_bleed_29_31  vw_route_29_31  vss  10000meg
XMN4_r_29_31  vw_route_29_31  we_route  iwrite_route_29_31  vss  sky130_fd_pr__nfet_01v8  w=0.5  l=0.5
X_rhebb_29_31  iwrite_route_29_31  inp_upper_31  ierr_dig_29  vcm_route  vdd vss  hebbian_mult

* ── Destination row 30 ── 32 source connections ──────────────────────────
XMPRED_r_30_0  i_pred_30  vw_route_30_0  vss  vss  sky130_fd_pr__nfet_01v8  w=4  l=0.35
Cw_route_30_0  vw_route_30_0  vss  200f
R_bleed_30_0  vw_route_30_0  vss  10000meg
XMN4_r_30_0  vw_route_30_0  we_route  iwrite_route_30_0  vss  sky130_fd_pr__nfet_01v8  w=0.5  l=0.5
X_rhebb_30_0  iwrite_route_30_0  inp_upper_0  ierr_dig_30  vcm_route  vdd vss  hebbian_mult
XMPRED_r_30_1  i_pred_30  vw_route_30_1  vss  vss  sky130_fd_pr__nfet_01v8  w=4  l=0.35
Cw_route_30_1  vw_route_30_1  vss  200f
R_bleed_30_1  vw_route_30_1  vss  10000meg
XMN4_r_30_1  vw_route_30_1  we_route  iwrite_route_30_1  vss  sky130_fd_pr__nfet_01v8  w=0.5  l=0.5
X_rhebb_30_1  iwrite_route_30_1  inp_upper_1  ierr_dig_30  vcm_route  vdd vss  hebbian_mult
XMPRED_r_30_2  i_pred_30  vw_route_30_2  vss  vss  sky130_fd_pr__nfet_01v8  w=4  l=0.35
Cw_route_30_2  vw_route_30_2  vss  200f
R_bleed_30_2  vw_route_30_2  vss  10000meg
XMN4_r_30_2  vw_route_30_2  we_route  iwrite_route_30_2  vss  sky130_fd_pr__nfet_01v8  w=0.5  l=0.5
X_rhebb_30_2  iwrite_route_30_2  inp_upper_2  ierr_dig_30  vcm_route  vdd vss  hebbian_mult
XMPRED_r_30_3  i_pred_30  vw_route_30_3  vss  vss  sky130_fd_pr__nfet_01v8  w=4  l=0.35
Cw_route_30_3  vw_route_30_3  vss  200f
R_bleed_30_3  vw_route_30_3  vss  10000meg
XMN4_r_30_3  vw_route_30_3  we_route  iwrite_route_30_3  vss  sky130_fd_pr__nfet_01v8  w=0.5  l=0.5
X_rhebb_30_3  iwrite_route_30_3  inp_upper_3  ierr_dig_30  vcm_route  vdd vss  hebbian_mult
XMPRED_r_30_4  i_pred_30  vw_route_30_4  vss  vss  sky130_fd_pr__nfet_01v8  w=4  l=0.35
Cw_route_30_4  vw_route_30_4  vss  200f
R_bleed_30_4  vw_route_30_4  vss  10000meg
XMN4_r_30_4  vw_route_30_4  we_route  iwrite_route_30_4  vss  sky130_fd_pr__nfet_01v8  w=0.5  l=0.5
X_rhebb_30_4  iwrite_route_30_4  inp_upper_4  ierr_dig_30  vcm_route  vdd vss  hebbian_mult
XMPRED_r_30_5  i_pred_30  vw_route_30_5  vss  vss  sky130_fd_pr__nfet_01v8  w=4  l=0.35
Cw_route_30_5  vw_route_30_5  vss  200f
R_bleed_30_5  vw_route_30_5  vss  10000meg
XMN4_r_30_5  vw_route_30_5  we_route  iwrite_route_30_5  vss  sky130_fd_pr__nfet_01v8  w=0.5  l=0.5
X_rhebb_30_5  iwrite_route_30_5  inp_upper_5  ierr_dig_30  vcm_route  vdd vss  hebbian_mult
XMPRED_r_30_6  i_pred_30  vw_route_30_6  vss  vss  sky130_fd_pr__nfet_01v8  w=4  l=0.35
Cw_route_30_6  vw_route_30_6  vss  200f
R_bleed_30_6  vw_route_30_6  vss  10000meg
XMN4_r_30_6  vw_route_30_6  we_route  iwrite_route_30_6  vss  sky130_fd_pr__nfet_01v8  w=0.5  l=0.5
X_rhebb_30_6  iwrite_route_30_6  inp_upper_6  ierr_dig_30  vcm_route  vdd vss  hebbian_mult
XMPRED_r_30_7  i_pred_30  vw_route_30_7  vss  vss  sky130_fd_pr__nfet_01v8  w=4  l=0.35
Cw_route_30_7  vw_route_30_7  vss  200f
R_bleed_30_7  vw_route_30_7  vss  10000meg
XMN4_r_30_7  vw_route_30_7  we_route  iwrite_route_30_7  vss  sky130_fd_pr__nfet_01v8  w=0.5  l=0.5
X_rhebb_30_7  iwrite_route_30_7  inp_upper_7  ierr_dig_30  vcm_route  vdd vss  hebbian_mult
XMPRED_r_30_8  i_pred_30  vw_route_30_8  vss  vss  sky130_fd_pr__nfet_01v8  w=4  l=0.35
Cw_route_30_8  vw_route_30_8  vss  200f
R_bleed_30_8  vw_route_30_8  vss  10000meg
XMN4_r_30_8  vw_route_30_8  we_route  iwrite_route_30_8  vss  sky130_fd_pr__nfet_01v8  w=0.5  l=0.5
X_rhebb_30_8  iwrite_route_30_8  inp_upper_8  ierr_dig_30  vcm_route  vdd vss  hebbian_mult
XMPRED_r_30_9  i_pred_30  vw_route_30_9  vss  vss  sky130_fd_pr__nfet_01v8  w=4  l=0.35
Cw_route_30_9  vw_route_30_9  vss  200f
R_bleed_30_9  vw_route_30_9  vss  10000meg
XMN4_r_30_9  vw_route_30_9  we_route  iwrite_route_30_9  vss  sky130_fd_pr__nfet_01v8  w=0.5  l=0.5
X_rhebb_30_9  iwrite_route_30_9  inp_upper_9  ierr_dig_30  vcm_route  vdd vss  hebbian_mult
XMPRED_r_30_10  i_pred_30  vw_route_30_10  vss  vss  sky130_fd_pr__nfet_01v8  w=4  l=0.35
Cw_route_30_10  vw_route_30_10  vss  200f
R_bleed_30_10  vw_route_30_10  vss  10000meg
XMN4_r_30_10  vw_route_30_10  we_route  iwrite_route_30_10  vss  sky130_fd_pr__nfet_01v8  w=0.5  l=0.5
X_rhebb_30_10  iwrite_route_30_10  inp_upper_10  ierr_dig_30  vcm_route  vdd vss  hebbian_mult
XMPRED_r_30_11  i_pred_30  vw_route_30_11  vss  vss  sky130_fd_pr__nfet_01v8  w=4  l=0.35
Cw_route_30_11  vw_route_30_11  vss  200f
R_bleed_30_11  vw_route_30_11  vss  10000meg
XMN4_r_30_11  vw_route_30_11  we_route  iwrite_route_30_11  vss  sky130_fd_pr__nfet_01v8  w=0.5  l=0.5
X_rhebb_30_11  iwrite_route_30_11  inp_upper_11  ierr_dig_30  vcm_route  vdd vss  hebbian_mult
XMPRED_r_30_12  i_pred_30  vw_route_30_12  vss  vss  sky130_fd_pr__nfet_01v8  w=4  l=0.35
Cw_route_30_12  vw_route_30_12  vss  200f
R_bleed_30_12  vw_route_30_12  vss  10000meg
XMN4_r_30_12  vw_route_30_12  we_route  iwrite_route_30_12  vss  sky130_fd_pr__nfet_01v8  w=0.5  l=0.5
X_rhebb_30_12  iwrite_route_30_12  inp_upper_12  ierr_dig_30  vcm_route  vdd vss  hebbian_mult
XMPRED_r_30_13  i_pred_30  vw_route_30_13  vss  vss  sky130_fd_pr__nfet_01v8  w=4  l=0.35
Cw_route_30_13  vw_route_30_13  vss  200f
R_bleed_30_13  vw_route_30_13  vss  10000meg
XMN4_r_30_13  vw_route_30_13  we_route  iwrite_route_30_13  vss  sky130_fd_pr__nfet_01v8  w=0.5  l=0.5
X_rhebb_30_13  iwrite_route_30_13  inp_upper_13  ierr_dig_30  vcm_route  vdd vss  hebbian_mult
XMPRED_r_30_14  i_pred_30  vw_route_30_14  vss  vss  sky130_fd_pr__nfet_01v8  w=4  l=0.35
Cw_route_30_14  vw_route_30_14  vss  200f
R_bleed_30_14  vw_route_30_14  vss  10000meg
XMN4_r_30_14  vw_route_30_14  we_route  iwrite_route_30_14  vss  sky130_fd_pr__nfet_01v8  w=0.5  l=0.5
X_rhebb_30_14  iwrite_route_30_14  inp_upper_14  ierr_dig_30  vcm_route  vdd vss  hebbian_mult
XMPRED_r_30_15  i_pred_30  vw_route_30_15  vss  vss  sky130_fd_pr__nfet_01v8  w=4  l=0.35
Cw_route_30_15  vw_route_30_15  vss  200f
R_bleed_30_15  vw_route_30_15  vss  10000meg
XMN4_r_30_15  vw_route_30_15  we_route  iwrite_route_30_15  vss  sky130_fd_pr__nfet_01v8  w=0.5  l=0.5
X_rhebb_30_15  iwrite_route_30_15  inp_upper_15  ierr_dig_30  vcm_route  vdd vss  hebbian_mult
XMPRED_r_30_16  i_pred_30  vw_route_30_16  vss  vss  sky130_fd_pr__nfet_01v8  w=4  l=0.35
Cw_route_30_16  vw_route_30_16  vss  200f
R_bleed_30_16  vw_route_30_16  vss  10000meg
XMN4_r_30_16  vw_route_30_16  we_route  iwrite_route_30_16  vss  sky130_fd_pr__nfet_01v8  w=0.5  l=0.5
X_rhebb_30_16  iwrite_route_30_16  inp_upper_16  ierr_dig_30  vcm_route  vdd vss  hebbian_mult
XMPRED_r_30_17  i_pred_30  vw_route_30_17  vss  vss  sky130_fd_pr__nfet_01v8  w=4  l=0.35
Cw_route_30_17  vw_route_30_17  vss  200f
R_bleed_30_17  vw_route_30_17  vss  10000meg
XMN4_r_30_17  vw_route_30_17  we_route  iwrite_route_30_17  vss  sky130_fd_pr__nfet_01v8  w=0.5  l=0.5
X_rhebb_30_17  iwrite_route_30_17  inp_upper_17  ierr_dig_30  vcm_route  vdd vss  hebbian_mult
XMPRED_r_30_18  i_pred_30  vw_route_30_18  vss  vss  sky130_fd_pr__nfet_01v8  w=4  l=0.35
Cw_route_30_18  vw_route_30_18  vss  200f
R_bleed_30_18  vw_route_30_18  vss  10000meg
XMN4_r_30_18  vw_route_30_18  we_route  iwrite_route_30_18  vss  sky130_fd_pr__nfet_01v8  w=0.5  l=0.5
X_rhebb_30_18  iwrite_route_30_18  inp_upper_18  ierr_dig_30  vcm_route  vdd vss  hebbian_mult
XMPRED_r_30_19  i_pred_30  vw_route_30_19  vss  vss  sky130_fd_pr__nfet_01v8  w=4  l=0.35
Cw_route_30_19  vw_route_30_19  vss  200f
R_bleed_30_19  vw_route_30_19  vss  10000meg
XMN4_r_30_19  vw_route_30_19  we_route  iwrite_route_30_19  vss  sky130_fd_pr__nfet_01v8  w=0.5  l=0.5
X_rhebb_30_19  iwrite_route_30_19  inp_upper_19  ierr_dig_30  vcm_route  vdd vss  hebbian_mult
XMPRED_r_30_20  i_pred_30  vw_route_30_20  vss  vss  sky130_fd_pr__nfet_01v8  w=4  l=0.35
Cw_route_30_20  vw_route_30_20  vss  200f
R_bleed_30_20  vw_route_30_20  vss  10000meg
XMN4_r_30_20  vw_route_30_20  we_route  iwrite_route_30_20  vss  sky130_fd_pr__nfet_01v8  w=0.5  l=0.5
X_rhebb_30_20  iwrite_route_30_20  inp_upper_20  ierr_dig_30  vcm_route  vdd vss  hebbian_mult
XMPRED_r_30_21  i_pred_30  vw_route_30_21  vss  vss  sky130_fd_pr__nfet_01v8  w=4  l=0.35
Cw_route_30_21  vw_route_30_21  vss  200f
R_bleed_30_21  vw_route_30_21  vss  10000meg
XMN4_r_30_21  vw_route_30_21  we_route  iwrite_route_30_21  vss  sky130_fd_pr__nfet_01v8  w=0.5  l=0.5
X_rhebb_30_21  iwrite_route_30_21  inp_upper_21  ierr_dig_30  vcm_route  vdd vss  hebbian_mult
XMPRED_r_30_22  i_pred_30  vw_route_30_22  vss  vss  sky130_fd_pr__nfet_01v8  w=4  l=0.35
Cw_route_30_22  vw_route_30_22  vss  200f
R_bleed_30_22  vw_route_30_22  vss  10000meg
XMN4_r_30_22  vw_route_30_22  we_route  iwrite_route_30_22  vss  sky130_fd_pr__nfet_01v8  w=0.5  l=0.5
X_rhebb_30_22  iwrite_route_30_22  inp_upper_22  ierr_dig_30  vcm_route  vdd vss  hebbian_mult
XMPRED_r_30_23  i_pred_30  vw_route_30_23  vss  vss  sky130_fd_pr__nfet_01v8  w=4  l=0.35
Cw_route_30_23  vw_route_30_23  vss  200f
R_bleed_30_23  vw_route_30_23  vss  10000meg
XMN4_r_30_23  vw_route_30_23  we_route  iwrite_route_30_23  vss  sky130_fd_pr__nfet_01v8  w=0.5  l=0.5
X_rhebb_30_23  iwrite_route_30_23  inp_upper_23  ierr_dig_30  vcm_route  vdd vss  hebbian_mult
XMPRED_r_30_24  i_pred_30  vw_route_30_24  vss  vss  sky130_fd_pr__nfet_01v8  w=4  l=0.35
Cw_route_30_24  vw_route_30_24  vss  200f
R_bleed_30_24  vw_route_30_24  vss  10000meg
XMN4_r_30_24  vw_route_30_24  we_route  iwrite_route_30_24  vss  sky130_fd_pr__nfet_01v8  w=0.5  l=0.5
X_rhebb_30_24  iwrite_route_30_24  inp_upper_24  ierr_dig_30  vcm_route  vdd vss  hebbian_mult
XMPRED_r_30_25  i_pred_30  vw_route_30_25  vss  vss  sky130_fd_pr__nfet_01v8  w=4  l=0.35
Cw_route_30_25  vw_route_30_25  vss  200f
R_bleed_30_25  vw_route_30_25  vss  10000meg
XMN4_r_30_25  vw_route_30_25  we_route  iwrite_route_30_25  vss  sky130_fd_pr__nfet_01v8  w=0.5  l=0.5
X_rhebb_30_25  iwrite_route_30_25  inp_upper_25  ierr_dig_30  vcm_route  vdd vss  hebbian_mult
XMPRED_r_30_26  i_pred_30  vw_route_30_26  vss  vss  sky130_fd_pr__nfet_01v8  w=4  l=0.35
Cw_route_30_26  vw_route_30_26  vss  200f
R_bleed_30_26  vw_route_30_26  vss  10000meg
XMN4_r_30_26  vw_route_30_26  we_route  iwrite_route_30_26  vss  sky130_fd_pr__nfet_01v8  w=0.5  l=0.5
X_rhebb_30_26  iwrite_route_30_26  inp_upper_26  ierr_dig_30  vcm_route  vdd vss  hebbian_mult
XMPRED_r_30_27  i_pred_30  vw_route_30_27  vss  vss  sky130_fd_pr__nfet_01v8  w=4  l=0.35
Cw_route_30_27  vw_route_30_27  vss  200f
R_bleed_30_27  vw_route_30_27  vss  10000meg
XMN4_r_30_27  vw_route_30_27  we_route  iwrite_route_30_27  vss  sky130_fd_pr__nfet_01v8  w=0.5  l=0.5
X_rhebb_30_27  iwrite_route_30_27  inp_upper_27  ierr_dig_30  vcm_route  vdd vss  hebbian_mult
XMPRED_r_30_28  i_pred_30  vw_route_30_28  vss  vss  sky130_fd_pr__nfet_01v8  w=4  l=0.35
Cw_route_30_28  vw_route_30_28  vss  200f
R_bleed_30_28  vw_route_30_28  vss  10000meg
XMN4_r_30_28  vw_route_30_28  we_route  iwrite_route_30_28  vss  sky130_fd_pr__nfet_01v8  w=0.5  l=0.5
X_rhebb_30_28  iwrite_route_30_28  inp_upper_28  ierr_dig_30  vcm_route  vdd vss  hebbian_mult
XMPRED_r_30_29  i_pred_30  vw_route_30_29  vss  vss  sky130_fd_pr__nfet_01v8  w=4  l=0.35
Cw_route_30_29  vw_route_30_29  vss  200f
R_bleed_30_29  vw_route_30_29  vss  10000meg
XMN4_r_30_29  vw_route_30_29  we_route  iwrite_route_30_29  vss  sky130_fd_pr__nfet_01v8  w=0.5  l=0.5
X_rhebb_30_29  iwrite_route_30_29  inp_upper_29  ierr_dig_30  vcm_route  vdd vss  hebbian_mult
XMPRED_r_30_30  i_pred_30  vw_route_30_30  vss  vss  sky130_fd_pr__nfet_01v8  w=4  l=0.35
Cw_route_30_30  vw_route_30_30  vss  200f
R_bleed_30_30  vw_route_30_30  vss  10000meg
XMN4_r_30_30  vw_route_30_30  we_route  iwrite_route_30_30  vss  sky130_fd_pr__nfet_01v8  w=0.5  l=0.5
X_rhebb_30_30  iwrite_route_30_30  inp_upper_30  ierr_dig_30  vcm_route  vdd vss  hebbian_mult
XMPRED_r_30_31  i_pred_30  vw_route_30_31  vss  vss  sky130_fd_pr__nfet_01v8  w=4  l=0.35
Cw_route_30_31  vw_route_30_31  vss  200f
R_bleed_30_31  vw_route_30_31  vss  10000meg
XMN4_r_30_31  vw_route_30_31  we_route  iwrite_route_30_31  vss  sky130_fd_pr__nfet_01v8  w=0.5  l=0.5
X_rhebb_30_31  iwrite_route_30_31  inp_upper_31  ierr_dig_30  vcm_route  vdd vss  hebbian_mult

* ── Destination row 31 ── 32 source connections ──────────────────────────
XMPRED_r_31_0  i_pred_31  vw_route_31_0  vss  vss  sky130_fd_pr__nfet_01v8  w=4  l=0.35
Cw_route_31_0  vw_route_31_0  vss  200f
R_bleed_31_0  vw_route_31_0  vss  10000meg
XMN4_r_31_0  vw_route_31_0  we_route  iwrite_route_31_0  vss  sky130_fd_pr__nfet_01v8  w=0.5  l=0.5
X_rhebb_31_0  iwrite_route_31_0  inp_upper_0  ierr_dig_31  vcm_route  vdd vss  hebbian_mult
XMPRED_r_31_1  i_pred_31  vw_route_31_1  vss  vss  sky130_fd_pr__nfet_01v8  w=4  l=0.35
Cw_route_31_1  vw_route_31_1  vss  200f
R_bleed_31_1  vw_route_31_1  vss  10000meg
XMN4_r_31_1  vw_route_31_1  we_route  iwrite_route_31_1  vss  sky130_fd_pr__nfet_01v8  w=0.5  l=0.5
X_rhebb_31_1  iwrite_route_31_1  inp_upper_1  ierr_dig_31  vcm_route  vdd vss  hebbian_mult
XMPRED_r_31_2  i_pred_31  vw_route_31_2  vss  vss  sky130_fd_pr__nfet_01v8  w=4  l=0.35
Cw_route_31_2  vw_route_31_2  vss  200f
R_bleed_31_2  vw_route_31_2  vss  10000meg
XMN4_r_31_2  vw_route_31_2  we_route  iwrite_route_31_2  vss  sky130_fd_pr__nfet_01v8  w=0.5  l=0.5
X_rhebb_31_2  iwrite_route_31_2  inp_upper_2  ierr_dig_31  vcm_route  vdd vss  hebbian_mult
XMPRED_r_31_3  i_pred_31  vw_route_31_3  vss  vss  sky130_fd_pr__nfet_01v8  w=4  l=0.35
Cw_route_31_3  vw_route_31_3  vss  200f
R_bleed_31_3  vw_route_31_3  vss  10000meg
XMN4_r_31_3  vw_route_31_3  we_route  iwrite_route_31_3  vss  sky130_fd_pr__nfet_01v8  w=0.5  l=0.5
X_rhebb_31_3  iwrite_route_31_3  inp_upper_3  ierr_dig_31  vcm_route  vdd vss  hebbian_mult
XMPRED_r_31_4  i_pred_31  vw_route_31_4  vss  vss  sky130_fd_pr__nfet_01v8  w=4  l=0.35
Cw_route_31_4  vw_route_31_4  vss  200f
R_bleed_31_4  vw_route_31_4  vss  10000meg
XMN4_r_31_4  vw_route_31_4  we_route  iwrite_route_31_4  vss  sky130_fd_pr__nfet_01v8  w=0.5  l=0.5
X_rhebb_31_4  iwrite_route_31_4  inp_upper_4  ierr_dig_31  vcm_route  vdd vss  hebbian_mult
XMPRED_r_31_5  i_pred_31  vw_route_31_5  vss  vss  sky130_fd_pr__nfet_01v8  w=4  l=0.35
Cw_route_31_5  vw_route_31_5  vss  200f
R_bleed_31_5  vw_route_31_5  vss  10000meg
XMN4_r_31_5  vw_route_31_5  we_route  iwrite_route_31_5  vss  sky130_fd_pr__nfet_01v8  w=0.5  l=0.5
X_rhebb_31_5  iwrite_route_31_5  inp_upper_5  ierr_dig_31  vcm_route  vdd vss  hebbian_mult
XMPRED_r_31_6  i_pred_31  vw_route_31_6  vss  vss  sky130_fd_pr__nfet_01v8  w=4  l=0.35
Cw_route_31_6  vw_route_31_6  vss  200f
R_bleed_31_6  vw_route_31_6  vss  10000meg
XMN4_r_31_6  vw_route_31_6  we_route  iwrite_route_31_6  vss  sky130_fd_pr__nfet_01v8  w=0.5  l=0.5
X_rhebb_31_6  iwrite_route_31_6  inp_upper_6  ierr_dig_31  vcm_route  vdd vss  hebbian_mult
XMPRED_r_31_7  i_pred_31  vw_route_31_7  vss  vss  sky130_fd_pr__nfet_01v8  w=4  l=0.35
Cw_route_31_7  vw_route_31_7  vss  200f
R_bleed_31_7  vw_route_31_7  vss  10000meg
XMN4_r_31_7  vw_route_31_7  we_route  iwrite_route_31_7  vss  sky130_fd_pr__nfet_01v8  w=0.5  l=0.5
X_rhebb_31_7  iwrite_route_31_7  inp_upper_7  ierr_dig_31  vcm_route  vdd vss  hebbian_mult
XMPRED_r_31_8  i_pred_31  vw_route_31_8  vss  vss  sky130_fd_pr__nfet_01v8  w=4  l=0.35
Cw_route_31_8  vw_route_31_8  vss  200f
R_bleed_31_8  vw_route_31_8  vss  10000meg
XMN4_r_31_8  vw_route_31_8  we_route  iwrite_route_31_8  vss  sky130_fd_pr__nfet_01v8  w=0.5  l=0.5
X_rhebb_31_8  iwrite_route_31_8  inp_upper_8  ierr_dig_31  vcm_route  vdd vss  hebbian_mult
XMPRED_r_31_9  i_pred_31  vw_route_31_9  vss  vss  sky130_fd_pr__nfet_01v8  w=4  l=0.35
Cw_route_31_9  vw_route_31_9  vss  200f
R_bleed_31_9  vw_route_31_9  vss  10000meg
XMN4_r_31_9  vw_route_31_9  we_route  iwrite_route_31_9  vss  sky130_fd_pr__nfet_01v8  w=0.5  l=0.5
X_rhebb_31_9  iwrite_route_31_9  inp_upper_9  ierr_dig_31  vcm_route  vdd vss  hebbian_mult
XMPRED_r_31_10  i_pred_31  vw_route_31_10  vss  vss  sky130_fd_pr__nfet_01v8  w=4  l=0.35
Cw_route_31_10  vw_route_31_10  vss  200f
R_bleed_31_10  vw_route_31_10  vss  10000meg
XMN4_r_31_10  vw_route_31_10  we_route  iwrite_route_31_10  vss  sky130_fd_pr__nfet_01v8  w=0.5  l=0.5
X_rhebb_31_10  iwrite_route_31_10  inp_upper_10  ierr_dig_31  vcm_route  vdd vss  hebbian_mult
XMPRED_r_31_11  i_pred_31  vw_route_31_11  vss  vss  sky130_fd_pr__nfet_01v8  w=4  l=0.35
Cw_route_31_11  vw_route_31_11  vss  200f
R_bleed_31_11  vw_route_31_11  vss  10000meg
XMN4_r_31_11  vw_route_31_11  we_route  iwrite_route_31_11  vss  sky130_fd_pr__nfet_01v8  w=0.5  l=0.5
X_rhebb_31_11  iwrite_route_31_11  inp_upper_11  ierr_dig_31  vcm_route  vdd vss  hebbian_mult
XMPRED_r_31_12  i_pred_31  vw_route_31_12  vss  vss  sky130_fd_pr__nfet_01v8  w=4  l=0.35
Cw_route_31_12  vw_route_31_12  vss  200f
R_bleed_31_12  vw_route_31_12  vss  10000meg
XMN4_r_31_12  vw_route_31_12  we_route  iwrite_route_31_12  vss  sky130_fd_pr__nfet_01v8  w=0.5  l=0.5
X_rhebb_31_12  iwrite_route_31_12  inp_upper_12  ierr_dig_31  vcm_route  vdd vss  hebbian_mult
XMPRED_r_31_13  i_pred_31  vw_route_31_13  vss  vss  sky130_fd_pr__nfet_01v8  w=4  l=0.35
Cw_route_31_13  vw_route_31_13  vss  200f
R_bleed_31_13  vw_route_31_13  vss  10000meg
XMN4_r_31_13  vw_route_31_13  we_route  iwrite_route_31_13  vss  sky130_fd_pr__nfet_01v8  w=0.5  l=0.5
X_rhebb_31_13  iwrite_route_31_13  inp_upper_13  ierr_dig_31  vcm_route  vdd vss  hebbian_mult
XMPRED_r_31_14  i_pred_31  vw_route_31_14  vss  vss  sky130_fd_pr__nfet_01v8  w=4  l=0.35
Cw_route_31_14  vw_route_31_14  vss  200f
R_bleed_31_14  vw_route_31_14  vss  10000meg
XMN4_r_31_14  vw_route_31_14  we_route  iwrite_route_31_14  vss  sky130_fd_pr__nfet_01v8  w=0.5  l=0.5
X_rhebb_31_14  iwrite_route_31_14  inp_upper_14  ierr_dig_31  vcm_route  vdd vss  hebbian_mult
XMPRED_r_31_15  i_pred_31  vw_route_31_15  vss  vss  sky130_fd_pr__nfet_01v8  w=4  l=0.35
Cw_route_31_15  vw_route_31_15  vss  200f
R_bleed_31_15  vw_route_31_15  vss  10000meg
XMN4_r_31_15  vw_route_31_15  we_route  iwrite_route_31_15  vss  sky130_fd_pr__nfet_01v8  w=0.5  l=0.5
X_rhebb_31_15  iwrite_route_31_15  inp_upper_15  ierr_dig_31  vcm_route  vdd vss  hebbian_mult
XMPRED_r_31_16  i_pred_31  vw_route_31_16  vss  vss  sky130_fd_pr__nfet_01v8  w=4  l=0.35
Cw_route_31_16  vw_route_31_16  vss  200f
R_bleed_31_16  vw_route_31_16  vss  10000meg
XMN4_r_31_16  vw_route_31_16  we_route  iwrite_route_31_16  vss  sky130_fd_pr__nfet_01v8  w=0.5  l=0.5
X_rhebb_31_16  iwrite_route_31_16  inp_upper_16  ierr_dig_31  vcm_route  vdd vss  hebbian_mult
XMPRED_r_31_17  i_pred_31  vw_route_31_17  vss  vss  sky130_fd_pr__nfet_01v8  w=4  l=0.35
Cw_route_31_17  vw_route_31_17  vss  200f
R_bleed_31_17  vw_route_31_17  vss  10000meg
XMN4_r_31_17  vw_route_31_17  we_route  iwrite_route_31_17  vss  sky130_fd_pr__nfet_01v8  w=0.5  l=0.5
X_rhebb_31_17  iwrite_route_31_17  inp_upper_17  ierr_dig_31  vcm_route  vdd vss  hebbian_mult
XMPRED_r_31_18  i_pred_31  vw_route_31_18  vss  vss  sky130_fd_pr__nfet_01v8  w=4  l=0.35
Cw_route_31_18  vw_route_31_18  vss  200f
R_bleed_31_18  vw_route_31_18  vss  10000meg
XMN4_r_31_18  vw_route_31_18  we_route  iwrite_route_31_18  vss  sky130_fd_pr__nfet_01v8  w=0.5  l=0.5
X_rhebb_31_18  iwrite_route_31_18  inp_upper_18  ierr_dig_31  vcm_route  vdd vss  hebbian_mult
XMPRED_r_31_19  i_pred_31  vw_route_31_19  vss  vss  sky130_fd_pr__nfet_01v8  w=4  l=0.35
Cw_route_31_19  vw_route_31_19  vss  200f
R_bleed_31_19  vw_route_31_19  vss  10000meg
XMN4_r_31_19  vw_route_31_19  we_route  iwrite_route_31_19  vss  sky130_fd_pr__nfet_01v8  w=0.5  l=0.5
X_rhebb_31_19  iwrite_route_31_19  inp_upper_19  ierr_dig_31  vcm_route  vdd vss  hebbian_mult
XMPRED_r_31_20  i_pred_31  vw_route_31_20  vss  vss  sky130_fd_pr__nfet_01v8  w=4  l=0.35
Cw_route_31_20  vw_route_31_20  vss  200f
R_bleed_31_20  vw_route_31_20  vss  10000meg
XMN4_r_31_20  vw_route_31_20  we_route  iwrite_route_31_20  vss  sky130_fd_pr__nfet_01v8  w=0.5  l=0.5
X_rhebb_31_20  iwrite_route_31_20  inp_upper_20  ierr_dig_31  vcm_route  vdd vss  hebbian_mult
XMPRED_r_31_21  i_pred_31  vw_route_31_21  vss  vss  sky130_fd_pr__nfet_01v8  w=4  l=0.35
Cw_route_31_21  vw_route_31_21  vss  200f
R_bleed_31_21  vw_route_31_21  vss  10000meg
XMN4_r_31_21  vw_route_31_21  we_route  iwrite_route_31_21  vss  sky130_fd_pr__nfet_01v8  w=0.5  l=0.5
X_rhebb_31_21  iwrite_route_31_21  inp_upper_21  ierr_dig_31  vcm_route  vdd vss  hebbian_mult
XMPRED_r_31_22  i_pred_31  vw_route_31_22  vss  vss  sky130_fd_pr__nfet_01v8  w=4  l=0.35
Cw_route_31_22  vw_route_31_22  vss  200f
R_bleed_31_22  vw_route_31_22  vss  10000meg
XMN4_r_31_22  vw_route_31_22  we_route  iwrite_route_31_22  vss  sky130_fd_pr__nfet_01v8  w=0.5  l=0.5
X_rhebb_31_22  iwrite_route_31_22  inp_upper_22  ierr_dig_31  vcm_route  vdd vss  hebbian_mult
XMPRED_r_31_23  i_pred_31  vw_route_31_23  vss  vss  sky130_fd_pr__nfet_01v8  w=4  l=0.35
Cw_route_31_23  vw_route_31_23  vss  200f
R_bleed_31_23  vw_route_31_23  vss  10000meg
XMN4_r_31_23  vw_route_31_23  we_route  iwrite_route_31_23  vss  sky130_fd_pr__nfet_01v8  w=0.5  l=0.5
X_rhebb_31_23  iwrite_route_31_23  inp_upper_23  ierr_dig_31  vcm_route  vdd vss  hebbian_mult
XMPRED_r_31_24  i_pred_31  vw_route_31_24  vss  vss  sky130_fd_pr__nfet_01v8  w=4  l=0.35
Cw_route_31_24  vw_route_31_24  vss  200f
R_bleed_31_24  vw_route_31_24  vss  10000meg
XMN4_r_31_24  vw_route_31_24  we_route  iwrite_route_31_24  vss  sky130_fd_pr__nfet_01v8  w=0.5  l=0.5
X_rhebb_31_24  iwrite_route_31_24  inp_upper_24  ierr_dig_31  vcm_route  vdd vss  hebbian_mult
XMPRED_r_31_25  i_pred_31  vw_route_31_25  vss  vss  sky130_fd_pr__nfet_01v8  w=4  l=0.35
Cw_route_31_25  vw_route_31_25  vss  200f
R_bleed_31_25  vw_route_31_25  vss  10000meg
XMN4_r_31_25  vw_route_31_25  we_route  iwrite_route_31_25  vss  sky130_fd_pr__nfet_01v8  w=0.5  l=0.5
X_rhebb_31_25  iwrite_route_31_25  inp_upper_25  ierr_dig_31  vcm_route  vdd vss  hebbian_mult
XMPRED_r_31_26  i_pred_31  vw_route_31_26  vss  vss  sky130_fd_pr__nfet_01v8  w=4  l=0.35
Cw_route_31_26  vw_route_31_26  vss  200f
R_bleed_31_26  vw_route_31_26  vss  10000meg
XMN4_r_31_26  vw_route_31_26  we_route  iwrite_route_31_26  vss  sky130_fd_pr__nfet_01v8  w=0.5  l=0.5
X_rhebb_31_26  iwrite_route_31_26  inp_upper_26  ierr_dig_31  vcm_route  vdd vss  hebbian_mult
XMPRED_r_31_27  i_pred_31  vw_route_31_27  vss  vss  sky130_fd_pr__nfet_01v8  w=4  l=0.35
Cw_route_31_27  vw_route_31_27  vss  200f
R_bleed_31_27  vw_route_31_27  vss  10000meg
XMN4_r_31_27  vw_route_31_27  we_route  iwrite_route_31_27  vss  sky130_fd_pr__nfet_01v8  w=0.5  l=0.5
X_rhebb_31_27  iwrite_route_31_27  inp_upper_27  ierr_dig_31  vcm_route  vdd vss  hebbian_mult
XMPRED_r_31_28  i_pred_31  vw_route_31_28  vss  vss  sky130_fd_pr__nfet_01v8  w=4  l=0.35
Cw_route_31_28  vw_route_31_28  vss  200f
R_bleed_31_28  vw_route_31_28  vss  10000meg
XMN4_r_31_28  vw_route_31_28  we_route  iwrite_route_31_28  vss  sky130_fd_pr__nfet_01v8  w=0.5  l=0.5
X_rhebb_31_28  iwrite_route_31_28  inp_upper_28  ierr_dig_31  vcm_route  vdd vss  hebbian_mult
XMPRED_r_31_29  i_pred_31  vw_route_31_29  vss  vss  sky130_fd_pr__nfet_01v8  w=4  l=0.35
Cw_route_31_29  vw_route_31_29  vss  200f
R_bleed_31_29  vw_route_31_29  vss  10000meg
XMN4_r_31_29  vw_route_31_29  we_route  iwrite_route_31_29  vss  sky130_fd_pr__nfet_01v8  w=0.5  l=0.5
X_rhebb_31_29  iwrite_route_31_29  inp_upper_29  ierr_dig_31  vcm_route  vdd vss  hebbian_mult
XMPRED_r_31_30  i_pred_31  vw_route_31_30  vss  vss  sky130_fd_pr__nfet_01v8  w=4  l=0.35
Cw_route_31_30  vw_route_31_30  vss  200f
R_bleed_31_30  vw_route_31_30  vss  10000meg
XMN4_r_31_30  vw_route_31_30  we_route  iwrite_route_31_30  vss  sky130_fd_pr__nfet_01v8  w=0.5  l=0.5
X_rhebb_31_30  iwrite_route_31_30  inp_upper_30  ierr_dig_31  vcm_route  vdd vss  hebbian_mult
XMPRED_r_31_31  i_pred_31  vw_route_31_31  vss  vss  sky130_fd_pr__nfet_01v8  w=4  l=0.35
Cw_route_31_31  vw_route_31_31  vss  200f
R_bleed_31_31  vw_route_31_31  vss  10000meg
XMN4_r_31_31  vw_route_31_31  we_route  iwrite_route_31_31  vss  sky130_fd_pr__nfet_01v8  w=0.5  l=0.5
X_rhebb_31_31  iwrite_route_31_31  inp_upper_31  ierr_dig_31  vcm_route  vdd vss  hebbian_mult

.ends layer_link_route_32
